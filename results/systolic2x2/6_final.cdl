* CDL Netlist generated by OpenROAD

*.BUSDELIMITER [

.SUBCKT systolic2x2 a_left[0] a_left[10] a_left[11] a_left[12]
+ a_left[13] a_left[14] a_left[15] a_left[1] a_left[2] a_left[3]
+ a_left[4] a_left[5] a_left[6] a_left[7] a_left[8] a_left[9]
+ b_top[0] b_top[10] b_top[11] b_top[12] b_top[13] b_top[14]
+ b_top[15] b_top[1] b_top[2] b_top[3] b_top[4] b_top[5] b_top[6]
+ b_top[7] b_top[8] b_top[9] c00[0] c00[10] c00[11] c00[12]
+ c00[13] c00[14] c00[15] c00[16] c00[17] c00[18] c00[19] c00[1]
+ c00[20] c00[21] c00[22] c00[23] c00[2] c00[3] c00[4] c00[5]
+ c00[6] c00[7] c00[8] c00[9] c01[0] c01[10] c01[11] c01[12]
+ c01[13] c01[14] c01[15] c01[16] c01[17] c01[18] c01[19] c01[1]
+ c01[20] c01[21] c01[22] c01[23] c01[2] c01[3] c01[4] c01[5]
+ c01[6] c01[7] c01[8] c01[9] c10[0] c10[10] c10[11] c10[12]
+ c10[13] c10[14] c10[15] c10[16] c10[17] c10[18] c10[19] c10[1]
+ c10[20] c10[21] c10[22] c10[23] c10[2] c10[3] c10[4] c10[5]
+ c10[6] c10[7] c10[8] c10[9] c11[0] c11[10] c11[11] c11[12]
+ c11[13] c11[14] c11[15] c11[16] c11[17] c11[18] c11[19] c11[1]
+ c11[20] c11[21] c11[22] c11[23] c11[2] c11[3] c11[4] c11[5]
+ c11[6] c11[7] c11[8] c11[9] clk done last reset start valid_in
+ VDD VSS
Xoutput122 net122 VSS VSS VDD VDD c11[21] sky130_fd_sc_hd__clkdlybuf4s50_1
Xoutput121 net121 VSS VSS VDD VDD c11[20] sky130_fd_sc_hd__clkdlybuf4s50_1
X_05125_ wrapped_design.b01_down\[0\] wrapped_design.a10_right\[2\]
+ VSS VSS VDD VDD _02527_ sky130_fd_sc_hd__nand2_1
X_05126_ _02527_ VSS VSS VDD VDD _02538_ sky130_fd_sc_hd__inv_1
Xoutput120 net120 VSS VSS VDD VDD c11[1] sky130_fd_sc_hd__clkdlybuf4s50_1
Xoutput119 net119 VSS VSS VDD VDD c11[19] sky130_fd_sc_hd__clkdlybuf4s50_1
X_05129_ _02538_ wrapped_design.b01_down\[1\] wrapped_design.a10_right\[3\]
+ VSS VSS VDD VDD _02571_ sky130_fd_sc_hd__nand3_1
Xoutput118 net118 VSS VSS VDD VDD c11[18] sky130_fd_sc_hd__clkdlybuf4s50_1
X_05131_ wrapped_design.b01_down\[1\] wrapped_design.a10_right\[4\]
+ VSS VSS VDD VDD _02593_ sky130_fd_sc_hd__nand2_1
X_05132_ wrapped_design.b01_down\[0\] wrapped_design.a10_right\[3\]
+ VSS VSS VDD VDD _02604_ sky130_fd_sc_hd__nand2_1
X_05133_ _02593_ _02604_ VSS VSS VDD VDD _02615_ sky130_fd_sc_hd__nor2_1
X_05134_ _02615_ VSS VSS VDD VDD _02626_ sky130_fd_sc_hd__inv_1
X_05135_ wrapped_design.b01_down\[0\] wrapped_design.a10_right\[4\]
+ VSS VSS VDD VDD _02637_ sky130_fd_sc_hd__nand2_1
X_05136_ wrapped_design.b01_down\[1\] wrapped_design.a10_right\[3\]
+ VSS VSS VDD VDD _02648_ sky130_fd_sc_hd__nand2_1
X_05137_ _02637_ _02648_ VSS VSS VDD VDD _02659_ sky130_fd_sc_hd__nand2_1
X_05138_ _02626_ _02659_ VSS VSS VDD VDD _02670_ sky130_fd_sc_hd__nand2_1
Xoutput117 net117 VSS VSS VDD VDD c11[17] sky130_fd_sc_hd__clkdlybuf4s50_1
Xoutput116 net116 VSS VSS VDD VDD c11[16] sky130_fd_sc_hd__clkdlybuf4s50_1
X_05141_ wrapped_design.b01_down\[3\] wrapped_design.a10_right\[1\]
+ VSS VSS VDD VDD _02703_ sky130_fd_sc_hd__nand2_1
Xoutput115 net115 VSS VSS VDD VDD c11[15] sky130_fd_sc_hd__clkdlybuf4s50_1
Xoutput114 net114 VSS VSS VDD VDD c11[14] sky130_fd_sc_hd__clkdlybuf4s50_1
X_05144_ wrapped_design.b01_down\[2\] wrapped_design.a10_right\[0\]
+ VSS VSS VDD VDD _02736_ sky130_fd_sc_hd__nand2_1
X_05145_ _02703_ _02736_ VSS VSS VDD VDD _02747_ sky130_fd_sc_hd__nor2_1
X_05146_ _02747_ VSS VSS VDD VDD _02758_ sky130_fd_sc_hd__inv_1
X_05147_ _02670_ _02758_ VSS VSS VDD VDD _02769_ sky130_fd_sc_hd__nand2_1
X_05148_ _02626_ _02747_ _02659_ VSS VSS VDD VDD _02780_ sky130_fd_sc_hd__nand3_1
X_05149_ _02769_ _02780_ VSS VSS VDD VDD _02791_ sky130_fd_sc_hd__nand2_1
X_05150_ _02571_ _02791_ VSS VSS VDD VDD _02802_ sky130_fd_sc_hd__or2_1
X_05151_ _02791_ _02571_ VSS VSS VDD VDD _02813_ sky130_fd_sc_hd__nand2_1
X_05152_ _02802_ _02813_ VSS VSS VDD VDD _02824_ sky130_fd_sc_hd__nand2_1
X_05153_ wrapped_design.b01_down\[2\] wrapped_design.a10_right\[2\]
+ VSS VSS VDD VDD _02835_ sky130_fd_sc_hd__nand2_1
Xoutput113 net113 VSS VSS VDD VDD c11[13] sky130_fd_sc_hd__clkdlybuf4s50_1
X_05155_ wrapped_design.b01_down\[4\] wrapped_design.a10_right\[1\]
+ VSS VSS VDD VDD _02857_ sky130_fd_sc_hd__nand2_1
X_05156_ wrapped_design.b01_down\[3\] wrapped_design.a10_right\[0\]
+ VSS VSS VDD VDD _02868_ sky130_fd_sc_hd__nand2_1
X_05157_ _02857_ _02868_ VSS VSS VDD VDD _02879_ sky130_fd_sc_hd__nor2_1
X_05158_ wrapped_design.b01_down\[4\] wrapped_design.a10_right\[0\]
+ VSS VSS VDD VDD _02890_ sky130_fd_sc_hd__nand2_1
X_05159_ _02703_ _02890_ VSS VSS VDD VDD _02901_ sky130_fd_sc_hd__nand2_1
X_05160_ _02901_ VSS VSS VDD VDD _02912_ sky130_fd_sc_hd__inv_1
X_05161_ _02879_ _02912_ VSS VSS VDD VDD _02923_ sky130_fd_sc_hd__nor2_1
X_05162_ _02835_ _02923_ VSS VSS VDD VDD _02934_ sky130_fd_sc_hd__xor2_1
X_05163_ _02824_ _02934_ VSS VSS VDD VDD _02945_ sky130_fd_sc_hd__nand2_1
X_05164_ _02934_ _02802_ _02813_ VSS VSS VDD VDD _02956_ sky130_fd_sc_hd__nand3b_2
X_05165_ wrapped_design.b01_down\[1\] wrapped_design.a10_right\[2\]
+ VSS VSS VDD VDD _02967_ sky130_fd_sc_hd__nand2_1
X_05166_ _02604_ _02967_ VSS VSS VDD VDD _02977_ sky130_fd_sc_hd__nand2_1
X_05167_ _02571_ _02977_ VSS VSS VDD VDD _02988_ sky130_fd_sc_hd__nand2_1
X_05168_ wrapped_design.b01_down\[1\] wrapped_design.a10_right\[1\]
+ VSS VSS VDD VDD _02999_ sky130_fd_sc_hd__nand2_1
X_05169_ _02999_ VSS VSS VDD VDD _03010_ sky130_fd_sc_hd__inv_1
X_05170_ _02538_ _03010_ VSS VSS VDD VDD _03020_ sky130_fd_sc_hd__nand2_1
X_05171_ _02988_ _03020_ VSS VSS VDD VDD _03031_ sky130_fd_sc_hd__nand2_1
X_05172_ _02977_ _02538_ _03010_ _02648_ VSS VSS VDD VDD _03042_
+ sky130_fd_sc_hd__nand4_1
X_05173_ wrapped_design.b01_down\[2\] wrapped_design.a10_right\[1\]
+ VSS VSS VDD VDD _03052_ sky130_fd_sc_hd__nand2_1
X_05174_ _02868_ _03052_ VSS VSS VDD VDD _03063_ sky130_fd_sc_hd__nand2_1
X_05175_ _03031_ _03042_ _02758_ _03063_ VSS VSS VDD VDD _03073_
+ sky130_fd_sc_hd__nand4_1
X_05176_ _03073_ _03042_ VSS VSS VDD VDD _03082_ sky130_fd_sc_hd__nand2_1
X_05177_ _02945_ _02956_ _03082_ VSS VSS VDD VDD _03092_ sky130_fd_sc_hd__nand3_1
X_05178_ _03092_ VSS VSS VDD VDD _03102_ sky130_fd_sc_hd__inv_1
X_05179_ _02527_ _02999_ VSS VSS VDD VDD _03112_ sky130_fd_sc_hd__nand2_1
X_05180_ _03020_ _03112_ VSS VSS VDD VDD _03121_ sky130_fd_sc_hd__nand2_1
X_05181_ wrapped_design.b01_down\[0\] wrapped_design.a10_right\[0\]
+ VSS VSS VDD VDD _03131_ sky130_fd_sc_hd__nand2_1
X_05182_ _02999_ _03131_ VSS VSS VDD VDD _03141_ sky130_fd_sc_hd__nor2_1
X_05183_ _03141_ VSS VSS VDD VDD _03150_ sky130_fd_sc_hd__inv_1
X_05184_ _03121_ _03150_ VSS VSS VDD VDD _03159_ sky130_fd_sc_hd__nand2_1
X_05185_ _03131_ VSS VSS VDD VDD _03169_ sky130_fd_sc_hd__inv_1
X_05186_ _03010_ _03169_ _02527_ VSS VSS VDD VDD _03178_ sky130_fd_sc_hd__nand3_1
X_05187_ _03159_ _03178_ VSS VSS VDD VDD _03186_ sky130_fd_sc_hd__nand2_1
X_05188_ _02736_ _03186_ VSS VSS VDD VDD _03194_ sky130_fd_sc_hd__nor2_1
X_05189_ _03194_ VSS VSS VDD VDD _03201_ sky130_fd_sc_hd__inv_1
X_05190_ _03201_ _03178_ VSS VSS VDD VDD _03209_ sky130_fd_sc_hd__nand2_1
X_05191_ _03031_ _03042_ VSS VSS VDD VDD _03217_ sky130_fd_sc_hd__nand2_1
X_05192_ _02758_ _03063_ VSS VSS VDD VDD _03225_ sky130_fd_sc_hd__nand2_1
X_05193_ _03217_ _03225_ VSS VSS VDD VDD _03233_ sky130_fd_sc_hd__nand2_1
X_05194_ _03209_ _03073_ _03233_ VSS VSS VDD VDD _03242_ sky130_fd_sc_hd__nand3_1
X_05195_ _02945_ _02956_ VSS VSS VDD VDD _03253_ sky130_fd_sc_hd__nand2_1
X_05196_ _03082_ VSS VSS VDD VDD _03264_ sky130_fd_sc_hd__inv_1
X_05197_ _03253_ _03264_ VSS VSS VDD VDD _03275_ sky130_fd_sc_hd__nand2_1
X_05198_ _03275_ _03092_ VSS VSS VDD VDD _03286_ sky130_fd_sc_hd__nand2_1
X_05199_ _03242_ _03286_ VSS VSS VDD VDD _03297_ sky130_fd_sc_hd__nor2_1
X_05200_ wrapped_design.b01_down\[4\] wrapped_design.a10_right\[2\]
+ VSS VSS VDD VDD _03308_ sky130_fd_sc_hd__nand2_1
X_05201_ _03308_ _02703_ VSS VSS VDD VDD _03319_ sky130_fd_sc_hd__nor2_1
X_05202_ _03319_ VSS VSS VDD VDD _03330_ sky130_fd_sc_hd__inv_1
X_05203_ wrapped_design.b01_down\[3\] wrapped_design.a10_right\[2\]
+ VSS VSS VDD VDD _03341_ sky130_fd_sc_hd__nand2_1
X_05204_ _03341_ _02857_ VSS VSS VDD VDD _03352_ sky130_fd_sc_hd__nand2_1
X_05205_ _03330_ _03352_ VSS VSS VDD VDD _03363_ sky130_fd_sc_hd__nand2_1
X_05206_ wrapped_design.b01_down\[2\] wrapped_design.a10_right\[3\]
+ VSS VSS VDD VDD _03374_ sky130_fd_sc_hd__nand2_1
X_05207_ _03363_ _03374_ VSS VSS VDD VDD _03385_ sky130_fd_sc_hd__nand2_1
X_05208_ _03374_ VSS VSS VDD VDD _03396_ sky130_fd_sc_hd__inv_1
X_05209_ _03330_ _03396_ _03352_ VSS VSS VDD VDD _03407_ sky130_fd_sc_hd__nand3_1
X_05210_ _03385_ _03407_ VSS VSS VDD VDD _03418_ sky130_fd_sc_hd__nand2_1
Xoutput112 net112 VSS VSS VDD VDD c11[12] sky130_fd_sc_hd__clkdlybuf4s50_1
X_05212_ wrapped_design.b01_down\[5\] wrapped_design.a10_right\[0\]
+ VSS VSS VDD VDD _03440_ sky130_fd_sc_hd__nand2_1
X_05213_ _03418_ _03440_ VSS VSS VDD VDD _03451_ sky130_fd_sc_hd__nand2_1
X_05214_ _03440_ VSS VSS VDD VDD _03462_ sky130_fd_sc_hd__inv_1
X_05215_ _03385_ _03462_ _03407_ VSS VSS VDD VDD _03473_ sky130_fd_sc_hd__nand3_1
X_05216_ _03451_ _03473_ VSS VSS VDD VDD _03484_ sky130_fd_sc_hd__nand2_1
X_05217_ _03484_ VSS VSS VDD VDD _03495_ sky130_fd_sc_hd__inv_1
X_05218_ _02835_ VSS VSS VDD VDD _03506_ sky130_fd_sc_hd__inv_1
X_05219_ _02901_ _03506_ _02879_ VSS VSS VDD VDD _03517_ sky130_fd_sc_hd__a21oi_1
X_05220_ _03517_ VSS VSS VDD VDD _03528_ sky130_fd_sc_hd__inv_1
X_05221_ wrapped_design.b01_down\[1\] wrapped_design.a10_right\[5\]
+ VSS VSS VDD VDD _03539_ sky130_fd_sc_hd__nand2_1
X_05222_ _03539_ _02637_ VSS VSS VDD VDD _03550_ sky130_fd_sc_hd__nor2_1
X_05223_ _03550_ VSS VSS VDD VDD _03561_ sky130_fd_sc_hd__inv_1
Xoutput111 net111 VSS VSS VDD VDD c11[11] sky130_fd_sc_hd__clkdlybuf4s50_1
X_05225_ wrapped_design.b01_down\[0\] wrapped_design.a10_right\[5\]
+ VSS VSS VDD VDD _03583_ sky130_fd_sc_hd__nand2_1
X_05226_ _03583_ _02593_ VSS VSS VDD VDD _03594_ sky130_fd_sc_hd__nand2_1
X_05227_ _03561_ _03594_ VSS VSS VDD VDD _03605_ sky130_fd_sc_hd__nand2_1
X_05228_ _03605_ VSS VSS VDD VDD _03616_ sky130_fd_sc_hd__inv_1
X_05229_ _03528_ _03616_ VSS VSS VDD VDD _03627_ sky130_fd_sc_hd__nand2_1
X_05230_ _03517_ _03605_ VSS VSS VDD VDD _03638_ sky130_fd_sc_hd__nand2_1
X_05231_ _03627_ _02615_ _03638_ VSS VSS VDD VDD _03649_ sky130_fd_sc_hd__nand3_1
X_05232_ _03627_ _03638_ VSS VSS VDD VDD _03660_ sky130_fd_sc_hd__nand2_1
X_05233_ _03660_ _02626_ VSS VSS VDD VDD _03671_ sky130_fd_sc_hd__nand2_1
X_05234_ _03495_ _03649_ _03671_ VSS VSS VDD VDD _03682_ sky130_fd_sc_hd__nand3_1
X_05235_ _03671_ _03649_ VSS VSS VDD VDD _03693_ sky130_fd_sc_hd__nand2_1
X_05236_ _03693_ _03484_ VSS VSS VDD VDD _03704_ sky130_fd_sc_hd__nand2_1
X_05237_ _03682_ _03704_ VSS VSS VDD VDD _03715_ sky130_fd_sc_hd__nand2_1
X_05238_ _02956_ VSS VSS VDD VDD _03726_ sky130_fd_sc_hd__inv_1
X_05239_ _03715_ _03726_ VSS VSS VDD VDD _03737_ sky130_fd_sc_hd__nand2_1
X_05240_ _03693_ _03495_ VSS VSS VDD VDD _03748_ sky130_fd_sc_hd__nand2_1
X_05241_ _03671_ _03484_ _03649_ VSS VSS VDD VDD _03759_ sky130_fd_sc_hd__nand3_1
X_05242_ _03748_ _03759_ VSS VSS VDD VDD _03770_ sky130_fd_sc_hd__nand2_1
X_05243_ _03770_ _02956_ VSS VSS VDD VDD _03781_ sky130_fd_sc_hd__nand2_1
X_05244_ _02802_ _02780_ VSS VSS VDD VDD _03792_ sky130_fd_sc_hd__nand2_1
X_05245_ _03737_ _03781_ _03792_ VSS VSS VDD VDD _03803_ sky130_fd_sc_hd__nand3_1
X_05246_ _03715_ _02956_ VSS VSS VDD VDD _03814_ sky130_fd_sc_hd__nand2_1
X_05247_ _03770_ _03726_ VSS VSS VDD VDD _03825_ sky130_fd_sc_hd__nand2_1
X_05248_ _03792_ VSS VSS VDD VDD _03836_ sky130_fd_sc_hd__inv_1
X_05249_ _03814_ _03825_ _03836_ VSS VSS VDD VDD _03847_ sky130_fd_sc_hd__nand3_1
X_05250_ _03803_ _03847_ VSS VSS VDD VDD _03858_ sky130_fd_sc_hd__nand2_1
X_05251_ _03102_ _03297_ _03858_ VSS VSS VDD VDD _03869_ sky130_fd_sc_hd__o21ai_2
X_05252_ _03814_ _03825_ _03792_ VSS VSS VDD VDD _03880_ sky130_fd_sc_hd__nand3_1
X_05253_ _03880_ _03825_ VSS VSS VDD VDD _03891_ sky130_fd_sc_hd__nand2_1
Xoutput110 net110 VSS VSS VDD VDD c11[10] sky130_fd_sc_hd__clkdlybuf4s50_1
X_05255_ wrapped_design.b01_down\[1\] wrapped_design.a10_right\[6\]
+ VSS VSS VDD VDD _03913_ sky130_fd_sc_hd__nand2_1
X_05256_ _03913_ _03583_ VSS VSS VDD VDD _03924_ sky130_fd_sc_hd__nor2_1
X_05257_ _03924_ VSS VSS VDD VDD _03935_ sky130_fd_sc_hd__inv_1
X_05258_ wrapped_design.b01_down\[0\] wrapped_design.a10_right\[6\]
+ VSS VSS VDD VDD _03946_ sky130_fd_sc_hd__nand2_1
X_05259_ _03946_ _03539_ VSS VSS VDD VDD _03957_ sky130_fd_sc_hd__nand2_1
X_05260_ _03935_ _03957_ VSS VSS VDD VDD _03968_ sky130_fd_sc_hd__nand2_1
X_05261_ _03352_ _03396_ _03319_ VSS VSS VDD VDD _03979_ sky130_fd_sc_hd__a21oi_1
X_05262_ _03968_ _03979_ VSS VSS VDD VDD _03990_ sky130_fd_sc_hd__nor2_1
X_05263_ _03990_ VSS VSS VDD VDD _04001_ sky130_fd_sc_hd__inv_1
X_05264_ _03979_ _03968_ VSS VSS VDD VDD _04012_ sky130_fd_sc_hd__nand2_1
X_05265_ _04001_ _04012_ VSS VSS VDD VDD _04023_ sky130_fd_sc_hd__nand2_1
X_05266_ _04023_ _03561_ VSS VSS VDD VDD _04034_ sky130_fd_sc_hd__nand2_1
X_05267_ _04012_ VSS VSS VDD VDD _04045_ sky130_fd_sc_hd__clkinv_1
X_05268_ _03990_ _04045_ VSS VSS VDD VDD _04056_ sky130_fd_sc_hd__nor2_1
X_05269_ _04056_ _03550_ VSS VSS VDD VDD _04067_ sky130_fd_sc_hd__nand2_1
X_05270_ _04034_ _04067_ VSS VSS VDD VDD _04078_ sky130_fd_sc_hd__nand2_1
X_05271_ _04078_ VSS VSS VDD VDD _04089_ sky130_fd_sc_hd__inv_2
X_05272_ wrapped_design.b01_down\[3\] wrapped_design.a10_right\[3\]
+ VSS VSS VDD VDD _04100_ sky130_fd_sc_hd__nand2_1
X_05273_ _04100_ VSS VSS VDD VDD _04111_ sky130_fd_sc_hd__inv_2
X_05274_ _03308_ VSS VSS VDD VDD _04122_ sky130_fd_sc_hd__inv_1
X_05275_ _04111_ _04122_ VSS VSS VDD VDD _04133_ sky130_fd_sc_hd__nand2_1
X_05276_ _04100_ _03308_ VSS VSS VDD VDD _04144_ sky130_fd_sc_hd__nand2_1
X_05277_ _04133_ _04144_ VSS VSS VDD VDD _04155_ sky130_fd_sc_hd__nand2_1
X_05278_ wrapped_design.b01_down\[2\] wrapped_design.a10_right\[4\]
+ VSS VSS VDD VDD _04166_ sky130_fd_sc_hd__nand2_1
X_05279_ _04155_ _04166_ VSS VSS VDD VDD _04177_ sky130_fd_sc_hd__nand2_1
X_05280_ _04166_ VSS VSS VDD VDD _04188_ sky130_fd_sc_hd__inv_1
X_05281_ _04133_ _04188_ _04144_ VSS VSS VDD VDD _04199_ sky130_fd_sc_hd__nand3_2
X_05282_ _04177_ _04199_ VSS VSS VDD VDD _04210_ sky130_fd_sc_hd__nand2_1
X_05283_ wrapped_design.b01_down\[6\] wrapped_design.a10_right\[1\]
+ VSS VSS VDD VDD _04221_ sky130_fd_sc_hd__nand2_2
X_05284_ _04221_ _03440_ VSS VSS VDD VDD _04232_ sky130_fd_sc_hd__nor2_2
X_05285_ _04232_ VSS VSS VDD VDD _04243_ sky130_fd_sc_hd__inv_2
X_05286_ wrapped_design.b01_down\[5\] wrapped_design.a10_right\[1\]
+ VSS VSS VDD VDD _04254_ sky130_fd_sc_hd__nand2_1
Xoutput109 net109 VSS VSS VDD VDD c11[0] sky130_fd_sc_hd__clkdlybuf4s50_1
X_05288_ wrapped_design.b01_down\[6\] wrapped_design.a10_right\[0\]
+ VSS VSS VDD VDD _04276_ sky130_fd_sc_hd__nand2_1
X_05289_ _04254_ _04276_ VSS VSS VDD VDD _04287_ sky130_fd_sc_hd__nand2_1
X_05290_ _04243_ _04287_ VSS VSS VDD VDD _04298_ sky130_fd_sc_hd__nand2_2
X_05291_ _04210_ _04298_ VSS VSS VDD VDD _04309_ sky130_fd_sc_hd__nand2_1
X_05292_ _04298_ VSS VSS VDD VDD _04320_ sky130_fd_sc_hd__inv_2
X_05293_ _04177_ _04320_ _04199_ VSS VSS VDD VDD _04331_ sky130_fd_sc_hd__nand3_2
X_05294_ _04309_ _04331_ VSS VSS VDD VDD _04342_ sky130_fd_sc_hd__nand2_1
X_05295_ _04342_ _03473_ VSS VSS VDD VDD _04353_ sky130_fd_sc_hd__nand2_1
X_05296_ _04210_ _04320_ VSS VSS VDD VDD _04364_ sky130_fd_sc_hd__nand2_1
X_05297_ _04177_ _04199_ _04298_ VSS VSS VDD VDD _04375_ sky130_fd_sc_hd__nand3_1
X_05298_ _04364_ _04375_ VSS VSS VDD VDD _04386_ sky130_fd_sc_hd__nand2_1
X_05299_ _03473_ VSS VSS VDD VDD _04396_ sky130_fd_sc_hd__inv_1
X_05300_ _04386_ _04396_ VSS VSS VDD VDD _04407_ sky130_fd_sc_hd__nand2_1
X_05301_ _04353_ _04407_ VSS VSS VDD VDD _04418_ sky130_fd_sc_hd__nand2_1
X_05302_ _04089_ _04418_ VSS VSS VDD VDD _04429_ sky130_fd_sc_hd__nand2_1
X_05303_ _03682_ VSS VSS VDD VDD _04440_ sky130_fd_sc_hd__inv_1
X_05304_ _04342_ _04396_ VSS VSS VDD VDD _04450_ sky130_fd_sc_hd__nand2_1
X_05305_ _04386_ _03473_ VSS VSS VDD VDD _04460_ sky130_fd_sc_hd__nand2_1
X_05306_ _04450_ _04460_ VSS VSS VDD VDD _04470_ sky130_fd_sc_hd__nand2_1
X_05307_ _04470_ _04078_ VSS VSS VDD VDD _04480_ sky130_fd_sc_hd__nand2_1
X_05308_ _04429_ _04440_ _04480_ VSS VSS VDD VDD _04490_ sky130_fd_sc_hd__nand3_1
X_05309_ _04089_ _04470_ VSS VSS VDD VDD _04499_ sky130_fd_sc_hd__nand2_2
X_05310_ _04418_ _04078_ VSS VSS VDD VDD _04509_ sky130_fd_sc_hd__nand2_1
X_05311_ _04499_ _04509_ _03682_ VSS VSS VDD VDD _04518_ sky130_fd_sc_hd__nand3_1
X_05312_ _03649_ _03627_ VSS VSS VDD VDD _04527_ sky130_fd_sc_hd__nand2_1
X_05313_ _04490_ _04518_ _04527_ VSS VSS VDD VDD _04536_ sky130_fd_sc_hd__nand3_1
X_05314_ _04499_ _04440_ _04509_ VSS VSS VDD VDD _04545_ sky130_fd_sc_hd__nand3_2
X_05315_ _04429_ _04480_ _03682_ VSS VSS VDD VDD _04555_ sky130_fd_sc_hd__nand3_1
X_05316_ _04527_ VSS VSS VDD VDD _04564_ sky130_fd_sc_hd__inv_1
X_05317_ _04545_ _04555_ _04564_ VSS VSS VDD VDD _04571_ sky130_fd_sc_hd__nand3_1
X_05318_ _04536_ _04571_ VSS VSS VDD VDD _04581_ sky130_fd_sc_hd__nand2_1
X_05319_ _03891_ _04581_ VSS VSS VDD VDD _04592_ sky130_fd_sc_hd__nor2_1
X_05320_ _04581_ _03891_ VSS VSS VDD VDD _04598_ sky130_fd_sc_hd__nand2_1
X_05321_ _03869_ _04592_ _04598_ VSS VSS VDD VDD _04607_ sky130_fd_sc_hd__o21ai_2
Xoutput108 net108 VSS VSS VDD VDD c10[9] sky130_fd_sc_hd__clkdlybuf4s50_1
X_05323_ wrapped_design.a10_right\[7\] wrapped_design.b01_down\[1\]
+ VSS VSS VDD VDD _04628_ sky130_fd_sc_hd__nand2_1
X_05324_ wrapped_design.a10_right\[7\] wrapped_design.b01_down\[0\]
+ VSS VSS VDD VDD _04639_ sky130_fd_sc_hd__nand2_1
X_05325_ _04639_ _03913_ VSS VSS VDD VDD _04646_ sky130_fd_sc_hd__nand2_1
X_05326_ _04628_ _03946_ _04646_ VSS VSS VDD VDD _04654_ sky130_fd_sc_hd__o21ai_1
X_05327_ _04654_ VSS VSS VDD VDD _04665_ sky130_fd_sc_hd__inv_1
Xoutput107 net107 VSS VSS VDD VDD c10[8] sky130_fd_sc_hd__clkdlybuf4s50_1
X_05329_ _04665_ wrapped_design.b01_down\[7\] VSS VSS VDD
+ VDD _04671_ sky130_fd_sc_hd__nand2_1
X_05330_ wrapped_design.b01_down\[7\] VSS VSS VDD VDD _04672_
+ sky130_fd_sc_hd__inv_2
X_05331_ _04654_ _04672_ VSS VSS VDD VDD _04673_ sky130_fd_sc_hd__nand2_1
X_05332_ _04671_ _04673_ VSS VSS VDD VDD _04674_ sky130_fd_sc_hd__nand2_1
X_05333_ _04199_ _04133_ VSS VSS VDD VDD _04675_ sky130_fd_sc_hd__nand2_1
X_05334_ _04675_ VSS VSS VDD VDD _04676_ sky130_fd_sc_hd__inv_1
X_05335_ _04674_ _04676_ VSS VSS VDD VDD _04677_ sky130_fd_sc_hd__nand2_1
X_05336_ _04675_ _04671_ _04673_ VSS VSS VDD VDD _04678_ sky130_fd_sc_hd__nand3_1
X_05337_ _04677_ _04678_ VSS VSS VDD VDD _04679_ sky130_fd_sc_hd__nand2_1
X_05338_ _04679_ _03935_ VSS VSS VDD VDD _04680_ sky130_fd_sc_hd__nand2_1
X_05339_ _04677_ _04678_ _03924_ VSS VSS VDD VDD _04681_ sky130_fd_sc_hd__nand3_1
X_05340_ _04680_ _04681_ VSS VSS VDD VDD _04682_ sky130_fd_sc_hd__nand2_1
X_05341_ _04682_ VSS VSS VDD VDD _04683_ sky130_fd_sc_hd__inv_2
X_05342_ wrapped_design.a10_right\[0\] _04672_ VSS VSS VDD
+ VDD _04684_ sky130_fd_sc_hd__nor2_1
X_05343_ _04221_ VSS VSS VDD VDD _04685_ sky130_fd_sc_hd__inv_2
X_05344_ _04684_ _04685_ VSS VSS VDD VDD _04686_ sky130_fd_sc_hd__nand2_2
X_05345_ wrapped_design.a10_right\[0\] VSS VSS VDD VDD _04687_
+ sky130_fd_sc_hd__inv_1
X_05346_ _04687_ wrapped_design.b01_down\[7\] VSS VSS VDD
+ VDD _04688_ sky130_fd_sc_hd__nand2_1
X_05347_ _04688_ _04221_ VSS VSS VDD VDD _04689_ sky130_fd_sc_hd__nand2_2
X_05348_ _04686_ _04689_ VSS VSS VDD VDD _04690_ sky130_fd_sc_hd__nand2_1
X_05349_ wrapped_design.b01_down\[5\] wrapped_design.a10_right\[2\]
+ VSS VSS VDD VDD _04691_ sky130_fd_sc_hd__nand2_1
X_05350_ _04691_ VSS VSS VDD VDD _04692_ sky130_fd_sc_hd__inv_1
X_05351_ _04690_ _04692_ VSS VSS VDD VDD _04693_ sky130_fd_sc_hd__nand2_1
X_05352_ _04686_ _04689_ _04691_ VSS VSS VDD VDD _04694_ sky130_fd_sc_hd__nand3_1
X_05353_ _04693_ _04694_ VSS VSS VDD VDD _04695_ sky130_fd_sc_hd__nand2_1
X_05354_ _04695_ _04232_ VSS VSS VDD VDD _04696_ sky130_fd_sc_hd__nand2_2
X_05355_ _04690_ _04691_ VSS VSS VDD VDD _04697_ sky130_fd_sc_hd__nand2_1
X_05356_ _04686_ _04689_ _04692_ VSS VSS VDD VDD _04698_ sky130_fd_sc_hd__nand3_1
X_05357_ _04697_ _04698_ VSS VSS VDD VDD _04699_ sky130_fd_sc_hd__nand2_1
X_05358_ _04699_ _04243_ VSS VSS VDD VDD _04700_ sky130_fd_sc_hd__nand2_1
X_05359_ wrapped_design.b01_down\[2\] wrapped_design.a10_right\[5\]
+ VSS VSS VDD VDD _04701_ sky130_fd_sc_hd__nand2_1
X_05360_ wrapped_design.b01_down\[4\] wrapped_design.a10_right\[4\]
+ VSS VSS VDD VDD _04702_ sky130_fd_sc_hd__nand2_1
X_05361_ _04702_ VSS VSS VDD VDD _04703_ sky130_fd_sc_hd__inv_2
X_05362_ _04703_ _04111_ VSS VSS VDD VDD _04704_ sky130_fd_sc_hd__nand2_1
X_05363_ wrapped_design.b01_down\[3\] wrapped_design.a10_right\[4\]
+ VSS VSS VDD VDD _04705_ sky130_fd_sc_hd__nand2_1
X_05364_ wrapped_design.b01_down\[4\] wrapped_design.a10_right\[3\]
+ VSS VSS VDD VDD _04706_ sky130_fd_sc_hd__nand2_1
X_05365_ _04705_ _04706_ VSS VSS VDD VDD _04707_ sky130_fd_sc_hd__nand2_1
X_05366_ _04704_ _04707_ VSS VSS VDD VDD _04708_ sky130_fd_sc_hd__nand2_1
X_05367_ _04701_ _04708_ VSS VSS VDD VDD _04709_ sky130_fd_sc_hd__nor2_1
X_05368_ _04709_ VSS VSS VDD VDD _04710_ sky130_fd_sc_hd__inv_1
X_05369_ _04708_ _04701_ VSS VSS VDD VDD _04711_ sky130_fd_sc_hd__nand2_1
X_05370_ _04710_ _04711_ VSS VSS VDD VDD _04712_ sky130_fd_sc_hd__nand2_1
X_05371_ _04696_ _04700_ _04712_ VSS VSS VDD VDD _04713_ sky130_fd_sc_hd__nand3_1
X_05372_ _04699_ _04232_ VSS VSS VDD VDD _04714_ sky130_fd_sc_hd__nand2_1
X_05373_ _04695_ _04243_ VSS VSS VDD VDD _04715_ sky130_fd_sc_hd__nand2_1
X_05374_ _04711_ VSS VSS VDD VDD _04716_ sky130_fd_sc_hd__inv_1
X_05375_ _04709_ _04716_ VSS VSS VDD VDD _04717_ sky130_fd_sc_hd__nor2_1
X_05376_ _04714_ _04715_ _04717_ VSS VSS VDD VDD _04718_ sky130_fd_sc_hd__nand3_1
X_05377_ _04713_ _04718_ VSS VSS VDD VDD _04719_ sky130_fd_sc_hd__nand2_1
X_05378_ _04331_ VSS VSS VDD VDD _04720_ sky130_fd_sc_hd__inv_1
X_05379_ _04719_ _04720_ VSS VSS VDD VDD _04721_ sky130_fd_sc_hd__nand2_1
X_05380_ _04714_ _04715_ _04712_ VSS VSS VDD VDD _04722_ sky130_fd_sc_hd__nand3_1
X_05381_ _04696_ _04700_ _04717_ VSS VSS VDD VDD _04723_ sky130_fd_sc_hd__nand3_1
X_05382_ _04722_ _04723_ VSS VSS VDD VDD _04724_ sky130_fd_sc_hd__nand2_1
X_05383_ _04724_ _04331_ VSS VSS VDD VDD _04725_ sky130_fd_sc_hd__nand2_1
X_05384_ _04683_ _04721_ _04725_ VSS VSS VDD VDD _04726_ sky130_fd_sc_hd__nand3_2
X_05385_ _04724_ _04720_ VSS VSS VDD VDD _04727_ sky130_fd_sc_hd__nand2_1
X_05386_ _04719_ _04331_ VSS VSS VDD VDD _04728_ sky130_fd_sc_hd__nand2_1
X_05387_ _04727_ _04728_ _04682_ VSS VSS VDD VDD _04729_ sky130_fd_sc_hd__nand3_1
X_05388_ _04726_ _04729_ VSS VSS VDD VDD _04730_ sky130_fd_sc_hd__nand2_1
X_05389_ _04499_ _04407_ VSS VSS VDD VDD _04731_ sky130_fd_sc_hd__nand2_2
X_05390_ _04730_ _04731_ VSS VSS VDD VDD _04732_ sky130_fd_sc_hd__nand2_1
X_05391_ _04731_ VSS VSS VDD VDD _04733_ sky130_fd_sc_hd__inv_1
X_05392_ _04733_ _04726_ _04729_ VSS VSS VDD VDD _04734_ sky130_fd_sc_hd__nand3_1
X_05393_ _04067_ _04001_ VSS VSS VDD VDD _04735_ sky130_fd_sc_hd__nand2_1
X_05394_ _04735_ VSS VSS VDD VDD _04736_ sky130_fd_sc_hd__inv_1
X_05395_ _04732_ _04734_ _04736_ VSS VSS VDD VDD _04737_ sky130_fd_sc_hd__nand3_1
X_05396_ _04730_ _04733_ VSS VSS VDD VDD _04738_ sky130_fd_sc_hd__nand2_1
X_05397_ _04726_ _04729_ _04731_ VSS VSS VDD VDD _04739_ sky130_fd_sc_hd__nand3_1
X_05398_ _04738_ _04739_ _04735_ VSS VSS VDD VDD _04740_ sky130_fd_sc_hd__nand3_2
X_05399_ _04737_ _04740_ VSS VSS VDD VDD _04741_ sky130_fd_sc_hd__nand2_1
X_05400_ _04545_ _04555_ _04527_ VSS VSS VDD VDD _04742_ sky130_fd_sc_hd__nand3_1
X_05401_ _04742_ _04545_ VSS VSS VDD VDD _04743_ sky130_fd_sc_hd__nand2_1
X_05402_ _04743_ VSS VSS VDD VDD _04744_ sky130_fd_sc_hd__inv_1
X_05403_ _04741_ _04744_ VSS VSS VDD VDD _04745_ sky130_fd_sc_hd__nand2_1
X_05404_ _04607_ _04745_ VSS VSS VDD VDD _04746_ sky130_fd_sc_hd__nand2_1
X_05405_ _04737_ _04740_ _04743_ VSS VSS VDD VDD _04747_ sky130_fd_sc_hd__nand3_1
X_05406_ _04746_ _04747_ VSS VSS VDD VDD _04748_ sky130_fd_sc_hd__nand2_1
X_05407_ wrapped_design.a10_right\[1\] _04672_ VSS VSS VDD
+ VDD _04749_ sky130_fd_sc_hd__nor2_1
X_05408_ wrapped_design.b01_down\[6\] wrapped_design.a10_right\[2\]
+ VSS VSS VDD VDD _04750_ sky130_fd_sc_hd__nand2_1
X_05409_ _04750_ VSS VSS VDD VDD _04751_ sky130_fd_sc_hd__inv_1
X_05410_ _04749_ _04751_ VSS VSS VDD VDD _04752_ sky130_fd_sc_hd__nand2_1
X_05411_ wrapped_design.a10_right\[1\] VSS VSS VDD VDD _04753_
+ sky130_fd_sc_hd__inv_1
X_05412_ _04753_ wrapped_design.b01_down\[7\] VSS VSS VDD
+ VDD _04754_ sky130_fd_sc_hd__nand2_1
X_05413_ _04754_ _04750_ VSS VSS VDD VDD _04755_ sky130_fd_sc_hd__nand2_1
X_05414_ _04752_ _04755_ VSS VSS VDD VDD _04756_ sky130_fd_sc_hd__nand2_1
X_05415_ wrapped_design.b01_down\[5\] wrapped_design.a10_right\[3\]
+ VSS VSS VDD VDD _04757_ sky130_fd_sc_hd__nand2_1
X_05416_ _04757_ VSS VSS VDD VDD _04758_ sky130_fd_sc_hd__inv_1
X_05417_ _04756_ _04758_ VSS VSS VDD VDD _04759_ sky130_fd_sc_hd__nand2_1
X_05418_ _04752_ _04755_ _04757_ VSS VSS VDD VDD _04760_ sky130_fd_sc_hd__nand3_1
X_05419_ _04759_ _04760_ VSS VSS VDD VDD _04761_ sky130_fd_sc_hd__nand2_1
X_05420_ _04698_ _04686_ VSS VSS VDD VDD _04762_ sky130_fd_sc_hd__nand2_1
X_05421_ _04761_ _04762_ VSS VSS VDD VDD _04763_ sky130_fd_sc_hd__nand2_1
X_05422_ _04756_ _04757_ VSS VSS VDD VDD _04764_ sky130_fd_sc_hd__nand2_1
X_05423_ _04752_ _04755_ _04758_ VSS VSS VDD VDD _04765_ sky130_fd_sc_hd__nand3_1
X_05424_ _04764_ _04765_ VSS VSS VDD VDD _04766_ sky130_fd_sc_hd__nand2_1
X_05425_ _04686_ VSS VSS VDD VDD _04767_ sky130_fd_sc_hd__inv_1
X_05426_ _04689_ _04692_ _04767_ VSS VSS VDD VDD _04768_ sky130_fd_sc_hd__a21oi_1
X_05427_ _04766_ _04768_ VSS VSS VDD VDD _04769_ sky130_fd_sc_hd__nand2_1
X_05428_ wrapped_design.b01_down\[3\] wrapped_design.a10_right\[5\]
+ VSS VSS VDD VDD _04770_ sky130_fd_sc_hd__nand2_1
X_05429_ _04770_ VSS VSS VDD VDD _04771_ sky130_fd_sc_hd__inv_2
X_05430_ _04771_ _04703_ VSS VSS VDD VDD _04772_ sky130_fd_sc_hd__nand2_1
X_05431_ _04770_ _04702_ VSS VSS VDD VDD _04773_ sky130_fd_sc_hd__nand2_1
X_05432_ _04772_ _04773_ VSS VSS VDD VDD _04774_ sky130_fd_sc_hd__nand2_1
X_05433_ wrapped_design.b01_down\[2\] wrapped_design.a10_right\[6\]
+ VSS VSS VDD VDD _04775_ sky130_fd_sc_hd__nand2_1
X_05434_ _04774_ _04775_ VSS VSS VDD VDD _04776_ sky130_fd_sc_hd__nand2_1
X_05435_ _04775_ _04772_ _04773_ VSS VSS VDD VDD _04777_ sky130_fd_sc_hd__nand3b_1
X_05436_ _04776_ _04777_ VSS VSS VDD VDD _04778_ sky130_fd_sc_hd__nand2_1
X_05437_ _04778_ VSS VSS VDD VDD _04779_ sky130_fd_sc_hd__inv_1
X_05438_ _04763_ _04769_ _04779_ VSS VSS VDD VDD _04780_ sky130_fd_sc_hd__nand3_1
X_05439_ _04766_ _04762_ VSS VSS VDD VDD _04781_ sky130_fd_sc_hd__nand2_1
X_05440_ _04761_ _04768_ VSS VSS VDD VDD _04782_ sky130_fd_sc_hd__nand2_1
X_05441_ _04781_ _04782_ _04778_ VSS VSS VDD VDD _04783_ sky130_fd_sc_hd__nand3_1
X_05442_ _04780_ _04783_ VSS VSS VDD VDD _04784_ sky130_fd_sc_hd__nand2_1
X_05443_ _04717_ _04700_ _04696_ VSS VSS VDD VDD _04785_ sky130_fd_sc_hd__a21boi_1
X_05444_ _04784_ _04785_ VSS VSS VDD VDD _04786_ sky130_fd_sc_hd__nand2_1
X_05445_ _04781_ _04782_ _04779_ VSS VSS VDD VDD _04787_ sky130_fd_sc_hd__nand3_1
X_05446_ _04763_ _04769_ _04778_ VSS VSS VDD VDD _04788_ sky130_fd_sc_hd__nand3_1
X_05447_ _04787_ _04788_ VSS VSS VDD VDD _04789_ sky130_fd_sc_hd__nand2_1
X_05448_ _04723_ _04696_ VSS VSS VDD VDD _04790_ sky130_fd_sc_hd__nand2_1
X_05449_ _04789_ _04790_ VSS VSS VDD VDD _04791_ sky130_fd_sc_hd__nand2_1
X_05450_ _04639_ _03913_ VSS VSS VDD VDD _04792_ sky130_fd_sc_hd__nor2_1
X_05451_ _04646_ wrapped_design.b01_down\[7\] _04792_ VSS
+ VSS VDD VDD _04793_ sky130_fd_sc_hd__a21oi_1
X_05452_ _04793_ VSS VSS VDD VDD _04794_ sky130_fd_sc_hd__inv_1
X_05453_ _04628_ _04639_ VSS VSS VDD VDD _04795_ sky130_fd_sc_hd__nand2_2
X_05454_ wrapped_design.a10_right\[7\] wrapped_design.b01_down\[0\]
+ wrapped_design.b01_down\[1\] VSS VSS VDD VDD _04796_ sky130_fd_sc_hd__nand3_1
X_05455_ _04795_ _04796_ VSS VSS VDD VDD _04797_ sky130_fd_sc_hd__nand2_1
X_05456_ _04701_ VSS VSS VDD VDD _04798_ sky130_fd_sc_hd__inv_1
X_05457_ _04702_ _04100_ VSS VSS VDD VDD _04799_ sky130_fd_sc_hd__nor2_1
X_05458_ _04707_ _04798_ _04799_ VSS VSS VDD VDD _04800_ sky130_fd_sc_hd__a21oi_1
X_05459_ _04797_ _04800_ VSS VSS VDD VDD _04801_ sky130_fd_sc_hd__nor2_1
X_05460_ _04800_ _04797_ VSS VSS VDD VDD _04802_ sky130_fd_sc_hd__nand2_1
X_05461_ _04802_ VSS VSS VDD VDD _04803_ sky130_fd_sc_hd__inv_1
X_05462_ _04801_ _04803_ VSS VSS VDD VDD _04804_ sky130_fd_sc_hd__nor2_1
X_05463_ _04794_ _04804_ VSS VSS VDD VDD _04805_ sky130_fd_sc_hd__nor2_1
X_05464_ _04804_ _04794_ VSS VSS VDD VDD _04806_ sky130_fd_sc_hd__nand2_1
X_05465_ _04806_ VSS VSS VDD VDD _04807_ sky130_fd_sc_hd__inv_1
X_05466_ _04805_ _04807_ VSS VSS VDD VDD _04808_ sky130_fd_sc_hd__nor2_1
X_05467_ _04786_ _04791_ _04808_ VSS VSS VDD VDD _04809_ sky130_fd_sc_hd__nand3_1
X_05468_ _04789_ _04785_ VSS VSS VDD VDD _04810_ sky130_fd_sc_hd__nand2_1
X_05469_ _04784_ _04790_ VSS VSS VDD VDD _04811_ sky130_fd_sc_hd__nand2_1
X_05470_ _04805_ VSS VSS VDD VDD _04812_ sky130_fd_sc_hd__inv_1
X_05471_ _04812_ _04806_ VSS VSS VDD VDD _04813_ sky130_fd_sc_hd__nand2_1
X_05472_ _04810_ _04811_ _04813_ VSS VSS VDD VDD _04814_ sky130_fd_sc_hd__nand3_1
X_05473_ _04809_ _04814_ VSS VSS VDD VDD _04815_ sky130_fd_sc_hd__nand2_1
X_05474_ _04726_ _04721_ VSS VSS VDD VDD _04816_ sky130_fd_sc_hd__nand2_1
X_05475_ _04815_ _04816_ VSS VSS VDD VDD _04817_ sky130_fd_sc_hd__nand2_1
X_05476_ _04810_ _04811_ _04808_ VSS VSS VDD VDD _04818_ sky130_fd_sc_hd__nand3_1
X_05477_ _04786_ _04791_ _04813_ VSS VSS VDD VDD _04819_ sky130_fd_sc_hd__nand3_1
X_05478_ _04818_ _04819_ VSS VSS VDD VDD _04820_ sky130_fd_sc_hd__nand2_1
X_05479_ _04683_ _04725_ _04721_ VSS VSS VDD VDD _04821_ sky130_fd_sc_hd__a21boi_1
X_05480_ _04820_ _04821_ VSS VSS VDD VDD _04822_ sky130_fd_sc_hd__nand2_1
X_05481_ _04681_ _04678_ VSS VSS VDD VDD _04823_ sky130_fd_sc_hd__nand2_1
X_05482_ _04817_ _04822_ _04823_ VSS VSS VDD VDD _04824_ sky130_fd_sc_hd__nand3_1
X_05483_ _04820_ _04816_ VSS VSS VDD VDD _04825_ sky130_fd_sc_hd__nand2_1
X_05484_ _04815_ _04821_ VSS VSS VDD VDD _04826_ sky130_fd_sc_hd__nand2_1
X_05485_ _04823_ VSS VSS VDD VDD _04827_ sky130_fd_sc_hd__inv_1
X_05486_ _04825_ _04826_ _04827_ VSS VSS VDD VDD _04828_ sky130_fd_sc_hd__nand3_1
X_05487_ _04824_ _04828_ VSS VSS VDD VDD _04829_ sky130_fd_sc_hd__nand2_1
X_05488_ _04740_ _04739_ VSS VSS VDD VDD _04830_ sky130_fd_sc_hd__nand2_1
X_05489_ _04829_ _04830_ VSS VSS VDD VDD _04831_ sky130_fd_sc_hd__nand2_1
X_05490_ _04825_ _04826_ _04823_ VSS VSS VDD VDD _04832_ sky130_fd_sc_hd__nand3_1
X_05491_ _04817_ _04822_ _04827_ VSS VSS VDD VDD _04833_ sky130_fd_sc_hd__nand3_1
X_05492_ _04832_ _04833_ VSS VSS VDD VDD _04834_ sky130_fd_sc_hd__nand2_1
X_05493_ _04735_ _04738_ _04739_ VSS VSS VDD VDD _04835_ sky130_fd_sc_hd__a21boi_1
X_05494_ _04834_ _04835_ VSS VSS VDD VDD _04836_ sky130_fd_sc_hd__nand2_1
X_05495_ _04831_ _04836_ VSS VSS VDD VDD _04837_ sky130_fd_sc_hd__nand2_1
X_05496_ _04765_ _04752_ VSS VSS VDD VDD _04838_ sky130_fd_sc_hd__nand2_1
X_05497_ _04838_ VSS VSS VDD VDD _04839_ sky130_fd_sc_hd__inv_1
X_05498_ wrapped_design.a10_right\[2\] VSS VSS VDD VDD _04840_
+ sky130_fd_sc_hd__inv_1
X_05499_ _04840_ wrapped_design.b01_down\[7\] wrapped_design.b01_down\[6\]
+ wrapped_design.a10_right\[3\] VSS VSS VDD VDD _04841_ sky130_fd_sc_hd__nand4_4
X_05500_ wrapped_design.b01_down\[6\] wrapped_design.a10_right\[3\]
+ VSS VSS VDD VDD _04842_ sky130_fd_sc_hd__nand2_1
X_05501_ wrapped_design.a10_right\[2\] _04672_ _04842_ VSS
+ VSS VDD VDD _04843_ sky130_fd_sc_hd__o21ai_2
X_05502_ _04841_ _04843_ VSS VSS VDD VDD _04844_ sky130_fd_sc_hd__nand2_1
X_05503_ wrapped_design.b01_down\[5\] wrapped_design.a10_right\[4\]
+ VSS VSS VDD VDD _04845_ sky130_fd_sc_hd__nand2_1
X_05504_ _04844_ _04845_ VSS VSS VDD VDD _04846_ sky130_fd_sc_hd__nand2_1
X_05505_ _04845_ VSS VSS VDD VDD _04847_ sky130_fd_sc_hd__inv_1
X_05506_ _04841_ _04843_ _04847_ VSS VSS VDD VDD _04848_ sky130_fd_sc_hd__nand3_1
X_05507_ _04846_ _04848_ VSS VSS VDD VDD _04849_ sky130_fd_sc_hd__nand2_1
X_05508_ _04839_ _04849_ VSS VSS VDD VDD _04850_ sky130_fd_sc_hd__nand2_1
X_05509_ _04844_ _04847_ VSS VSS VDD VDD _04851_ sky130_fd_sc_hd__nand2_1
X_05510_ _04841_ _04843_ _04845_ VSS VSS VDD VDD _04852_ sky130_fd_sc_hd__nand3_1
X_05511_ _04851_ _04852_ VSS VSS VDD VDD _04853_ sky130_fd_sc_hd__nand2_1
X_05512_ _04853_ _04838_ VSS VSS VDD VDD _04854_ sky130_fd_sc_hd__nand2_1
X_05513_ wrapped_design.b01_down\[4\] wrapped_design.a10_right\[6\]
+ VSS VSS VDD VDD _04855_ sky130_fd_sc_hd__nand2_1
X_05514_ _04855_ VSS VSS VDD VDD _04856_ sky130_fd_sc_hd__inv_1
X_05515_ _04856_ _04771_ VSS VSS VDD VDD _04857_ sky130_fd_sc_hd__nand2_1
X_05516_ wrapped_design.b01_down\[3\] wrapped_design.a10_right\[6\]
+ VSS VSS VDD VDD _04858_ sky130_fd_sc_hd__nand2_1
X_05517_ wrapped_design.b01_down\[4\] wrapped_design.a10_right\[5\]
+ VSS VSS VDD VDD _04859_ sky130_fd_sc_hd__nand2_1
X_05518_ _04858_ _04859_ VSS VSS VDD VDD _04860_ sky130_fd_sc_hd__nand2_1
X_05519_ _04857_ _04860_ VSS VSS VDD VDD _04861_ sky130_fd_sc_hd__nand2_1
X_05520_ wrapped_design.a10_right\[7\] wrapped_design.b01_down\[2\]
+ VSS VSS VDD VDD _04862_ sky130_fd_sc_hd__nand2_1
X_05521_ _04861_ _04862_ VSS VSS VDD VDD _04863_ sky130_fd_sc_hd__nand2_1
X_05522_ _04862_ VSS VSS VDD VDD _04864_ sky130_fd_sc_hd__inv_2
X_05523_ _04857_ _04864_ _04860_ VSS VSS VDD VDD _04865_ sky130_fd_sc_hd__nand3_1
X_05524_ _04863_ _04865_ VSS VSS VDD VDD _04866_ sky130_fd_sc_hd__nand2_1
X_05525_ _04866_ VSS VSS VDD VDD _04867_ sky130_fd_sc_hd__inv_1
X_05526_ _04850_ _04854_ _04867_ VSS VSS VDD VDD _04868_ sky130_fd_sc_hd__nand3_1
X_05527_ _04839_ _04853_ VSS VSS VDD VDD _04869_ sky130_fd_sc_hd__nand2_1
X_05528_ _04849_ _04838_ VSS VSS VDD VDD _04870_ sky130_fd_sc_hd__nand2_1
X_05529_ _04869_ _04870_ _04866_ VSS VSS VDD VDD _04871_ sky130_fd_sc_hd__nand3_1
X_05530_ _04868_ _04871_ VSS VSS VDD VDD _04872_ sky130_fd_sc_hd__nand2_1
X_05531_ _04779_ _04769_ _04763_ VSS VSS VDD VDD _04873_ sky130_fd_sc_hd__a21boi_1
X_05532_ _04872_ _04873_ VSS VSS VDD VDD _04874_ sky130_fd_sc_hd__nand2_1
X_05533_ _04869_ _04870_ _04867_ VSS VSS VDD VDD _04875_ sky130_fd_sc_hd__nand3_1
X_05534_ _04850_ _04854_ _04866_ VSS VSS VDD VDD _04876_ sky130_fd_sc_hd__nand3_1
X_05535_ _04875_ _04876_ VSS VSS VDD VDD _04877_ sky130_fd_sc_hd__nand2_1
X_05536_ _04780_ _04763_ VSS VSS VDD VDD _04878_ sky130_fd_sc_hd__nand2_1
X_05537_ _04877_ _04878_ VSS VSS VDD VDD _04879_ sky130_fd_sc_hd__nand2_1
X_05538_ _04795_ VSS VSS VDD VDD _04880_ sky130_fd_sc_hd__inv_2
X_05539_ _04777_ _04772_ VSS VSS VDD VDD _04881_ sky130_fd_sc_hd__nand2_1
X_05540_ _04881_ VSS VSS VDD VDD _04882_ sky130_fd_sc_hd__inv_1
X_05541_ _04880_ _04882_ VSS VSS VDD VDD _04883_ sky130_fd_sc_hd__nor2_2
X_05542_ _04883_ VSS VSS VDD VDD _04884_ sky130_fd_sc_hd__inv_2
X_05543_ _04882_ _04880_ VSS VSS VDD VDD _04885_ sky130_fd_sc_hd__nand2_1
X_05544_ _04884_ _04885_ VSS VSS VDD VDD _04886_ sky130_fd_sc_hd__nand2_1
X_05545_ _04886_ VSS VSS VDD VDD _04887_ sky130_fd_sc_hd__inv_2
X_05546_ _04874_ _04879_ _04887_ VSS VSS VDD VDD _04888_ sky130_fd_sc_hd__nand3_1
X_05547_ _04877_ _04873_ VSS VSS VDD VDD _04889_ sky130_fd_sc_hd__nand2_1
X_05548_ _04872_ _04878_ VSS VSS VDD VDD _04890_ sky130_fd_sc_hd__nand2_1
X_05549_ _04889_ _04890_ _04886_ VSS VSS VDD VDD _04891_ sky130_fd_sc_hd__nand3_1
X_05550_ _04888_ _04891_ VSS VSS VDD VDD _04892_ sky130_fd_sc_hd__nand2_1
X_05551_ _04808_ _04786_ _04791_ VSS VSS VDD VDD _04893_ sky130_fd_sc_hd__a21boi_1
X_05552_ _04892_ _04893_ VSS VSS VDD VDD _04894_ sky130_fd_sc_hd__nand2_1
X_05553_ _04889_ _04890_ _04887_ VSS VSS VDD VDD _04895_ sky130_fd_sc_hd__nand3_1
X_05554_ _04874_ _04879_ _04886_ VSS VSS VDD VDD _04896_ sky130_fd_sc_hd__nand3_1
X_05555_ _04895_ _04896_ VSS VSS VDD VDD _04897_ sky130_fd_sc_hd__nand2_1
X_05556_ _04809_ _04791_ VSS VSS VDD VDD _04898_ sky130_fd_sc_hd__nand2_1
X_05557_ _04897_ _04898_ VSS VSS VDD VDD _04899_ sky130_fd_sc_hd__nand2_1
X_05558_ _04801_ _04807_ VSS VSS VDD VDD _04900_ sky130_fd_sc_hd__nor2_1
X_05559_ _04900_ VSS VSS VDD VDD _04901_ sky130_fd_sc_hd__inv_1
X_05560_ _04894_ _04899_ _04901_ VSS VSS VDD VDD _04902_ sky130_fd_sc_hd__nand3_1
X_05561_ _04897_ _04893_ VSS VSS VDD VDD _04903_ sky130_fd_sc_hd__nand2_1
X_05562_ _04892_ _04898_ VSS VSS VDD VDD _04904_ sky130_fd_sc_hd__nand2_1
X_05563_ _04903_ _04904_ _04900_ VSS VSS VDD VDD _04905_ sky130_fd_sc_hd__nand3_1
X_05564_ _04902_ _04905_ VSS VSS VDD VDD _04906_ sky130_fd_sc_hd__nand2_1
X_05565_ _04823_ _04826_ _04825_ VSS VSS VDD VDD _04907_ sky130_fd_sc_hd__a21boi_0
X_05566_ _04906_ _04907_ VSS VSS VDD VDD _04908_ sky130_fd_sc_hd__nand2_1
X_05567_ _04903_ _04904_ _04901_ VSS VSS VDD VDD _04909_ sky130_fd_sc_hd__nand3_1
X_05568_ _04894_ _04899_ _04900_ VSS VSS VDD VDD _04910_ sky130_fd_sc_hd__nand3_1
X_05569_ _04909_ _04910_ VSS VSS VDD VDD _04911_ sky130_fd_sc_hd__nand2_1
X_05570_ _04832_ _04825_ VSS VSS VDD VDD _04912_ sky130_fd_sc_hd__nand2_1
X_05571_ _04911_ _04912_ VSS VSS VDD VDD _04913_ sky130_fd_sc_hd__nand2_1
X_05572_ _04908_ _04913_ VSS VSS VDD VDD _04914_ sky130_fd_sc_hd__nand2_1
X_05573_ _04837_ _04914_ VSS VSS VDD VDD _04915_ sky130_fd_sc_hd__nor2_1
X_05574_ _04748_ _04915_ VSS VSS VDD VDD _04916_ sky130_fd_sc_hd__nand2_1
X_05575_ _04831_ VSS VSS VDD VDD _04917_ sky130_fd_sc_hd__inv_2
X_05576_ _04913_ VSS VSS VDD VDD _04918_ sky130_fd_sc_hd__inv_1
X_05577_ _04917_ _04918_ _04908_ VSS VSS VDD VDD _04919_ sky130_fd_sc_hd__o21ai_1
X_05578_ _04916_ _04919_ VSS VSS VDD VDD _04920_ sky130_fd_sc_hd__nand2_1
X_05579_ wrapped_design.b01_down\[5\] wrapped_design.a10_right\[6\]
+ VSS VSS VDD VDD _04921_ sky130_fd_sc_hd__nand2_1
X_05580_ _04921_ VSS VSS VDD VDD _04922_ sky130_fd_sc_hd__inv_1
X_05581_ wrapped_design.a10_right\[4\] VSS VSS VDD VDD _04923_
+ sky130_fd_sc_hd__inv_1
X_05582_ _04923_ wrapped_design.b01_down\[7\] VSS VSS VDD
+ VDD _04924_ sky130_fd_sc_hd__nand2_1
X_05583_ wrapped_design.b01_down\[6\] wrapped_design.a10_right\[5\]
+ VSS VSS VDD VDD _04925_ sky130_fd_sc_hd__nand2_2
X_05584_ _04924_ _04925_ VSS VSS VDD VDD _04926_ sky130_fd_sc_hd__nand2_1
X_05585_ _04923_ wrapped_design.b01_down\[7\] wrapped_design.b01_down\[6\]
+ wrapped_design.a10_right\[5\] VSS VSS VDD VDD _04927_ sky130_fd_sc_hd__nand4_1
X_05586_ _04922_ _04926_ _04927_ VSS VSS VDD VDD _04928_ sky130_fd_sc_hd__a21boi_2
X_05587_ _04928_ VSS VSS VDD VDD _04929_ sky130_fd_sc_hd__clkinv_1
X_05588_ wrapped_design.a10_right\[5\] _04672_ VSS VSS VDD
+ VDD _04930_ sky130_fd_sc_hd__nor2_1
X_05589_ wrapped_design.b01_down\[6\] wrapped_design.a10_right\[6\]
+ VSS VSS VDD VDD _04931_ sky130_fd_sc_hd__nand2_1
X_05590_ _04931_ VSS VSS VDD VDD _04932_ sky130_fd_sc_hd__inv_1
X_05591_ _04930_ _04932_ VSS VSS VDD VDD _04933_ sky130_fd_sc_hd__nand2_1
X_05592_ wrapped_design.a10_right\[5\] VSS VSS VDD VDD _04934_
+ sky130_fd_sc_hd__inv_1
X_05593_ _04934_ wrapped_design.b01_down\[7\] VSS VSS VDD
+ VDD _04935_ sky130_fd_sc_hd__nand2_1
X_05594_ _04935_ _04931_ VSS VSS VDD VDD _04936_ sky130_fd_sc_hd__nand2_1
X_05595_ _04933_ _04936_ VSS VSS VDD VDD _04937_ sky130_fd_sc_hd__nand2_1
X_05596_ wrapped_design.a10_right\[7\] wrapped_design.b01_down\[5\]
+ VSS VSS VDD VDD _04938_ sky130_fd_sc_hd__nand2_1
X_05597_ _04937_ _04938_ VSS VSS VDD VDD _04939_ sky130_fd_sc_hd__nand2_1
X_05598_ _04938_ VSS VSS VDD VDD _04940_ sky130_fd_sc_hd__inv_1
X_05599_ _04933_ _04936_ _04940_ VSS VSS VDD VDD _04941_ sky130_fd_sc_hd__nand3_1
X_05600_ _04939_ _04941_ VSS VSS VDD VDD _04942_ sky130_fd_sc_hd__nand2_1
X_05601_ _04942_ VSS VSS VDD VDD _04943_ sky130_fd_sc_hd__inv_1
X_05602_ _04929_ _04943_ VSS VSS VDD VDD _04944_ sky130_fd_sc_hd__nand2_1
X_05603_ _04928_ _04942_ VSS VSS VDD VDD _04945_ sky130_fd_sc_hd__nand2_1
X_05604_ wrapped_design.a10_right\[7\] wrapped_design.b01_down\[3\]
+ VSS VSS VDD VDD _04946_ sky130_fd_sc_hd__nand2_1
X_05605_ _04946_ VSS VSS VDD VDD _04947_ sky130_fd_sc_hd__inv_1
X_05606_ _04947_ wrapped_design.b01_down\[4\] VSS VSS VDD
+ VDD _04948_ sky130_fd_sc_hd__nand2_1
X_05607_ wrapped_design.a10_right\[7\] wrapped_design.b01_down\[4\]
+ VSS VSS VDD VDD _04949_ sky130_fd_sc_hd__nand2_1
X_05608_ _04946_ _04949_ VSS VSS VDD VDD _04950_ sky130_fd_sc_hd__nand2_1
X_05609_ _04948_ _04950_ VSS VSS VDD VDD _04951_ sky130_fd_sc_hd__nand2_1
X_05610_ _04862_ _04951_ VSS VSS VDD VDD _04952_ sky130_fd_sc_hd__nor2_1
X_05611_ _04952_ VSS VSS VDD VDD _04953_ sky130_fd_sc_hd__inv_2
X_05612_ _04951_ _04862_ VSS VSS VDD VDD _04954_ sky130_fd_sc_hd__nand2_1
X_05613_ _04953_ _04954_ VSS VSS VDD VDD _04955_ sky130_fd_sc_hd__nand2_4
X_05614_ _04955_ VSS VSS VDD VDD _04956_ sky130_fd_sc_hd__inv_4
X_05615_ _04944_ _04945_ _04956_ VSS VSS VDD VDD _04957_ sky130_fd_sc_hd__nand3_2
X_05616_ _04957_ _04944_ VSS VSS VDD VDD _04958_ sky130_fd_sc_hd__nand2_1
X_05617_ _04958_ VSS VSS VDD VDD _04959_ sky130_fd_sc_hd__inv_2
X_05618_ wrapped_design.a10_right\[6\] VSS VSS VDD VDD _04960_
+ sky130_fd_sc_hd__inv_1
X_05619_ _04960_ wrapped_design.b01_down\[7\] wrapped_design.a10_right\[7\]
+ wrapped_design.b01_down\[6\] VSS VSS VDD VDD _04961_ sky130_fd_sc_hd__nand4_2
X_05620_ wrapped_design.a10_right\[7\] wrapped_design.b01_down\[6\]
+ VSS VSS VDD VDD _04962_ sky130_fd_sc_hd__nand2_1
X_05621_ wrapped_design.a10_right\[6\] _04672_ _04962_ VSS
+ VSS VDD VDD _04963_ sky130_fd_sc_hd__o21ai_2
X_05622_ _04961_ _04963_ VSS VSS VDD VDD _04964_ sky130_fd_sc_hd__nand2_1
X_05623_ _04964_ _04938_ VSS VSS VDD VDD _04965_ sky130_fd_sc_hd__nand2_1
X_05624_ _04961_ _04963_ _04940_ VSS VSS VDD VDD _04966_ sky130_fd_sc_hd__nand3_1
X_05625_ _04965_ _04966_ VSS VSS VDD VDD _04967_ sky130_fd_sc_hd__nand2_1
X_05626_ _04967_ VSS VSS VDD VDD _04968_ sky130_fd_sc_hd__inv_2
X_05627_ _04941_ _04933_ VSS VSS VDD VDD _04969_ sky130_fd_sc_hd__nand2_1
X_05628_ _04968_ _04969_ VSS VSS VDD VDD _04970_ sky130_fd_sc_hd__nand2_2
X_05629_ _04969_ VSS VSS VDD VDD _04971_ sky130_fd_sc_hd__inv_1
X_05630_ _04971_ _04967_ VSS VSS VDD VDD _04972_ sky130_fd_sc_hd__nand2_1
X_05631_ _04970_ _04956_ _04972_ VSS VSS VDD VDD _04973_ sky130_fd_sc_hd__nand3_2
X_05632_ _04968_ _04971_ VSS VSS VDD VDD _04974_ sky130_fd_sc_hd__nand2_1
X_05633_ _04967_ _04969_ VSS VSS VDD VDD _04975_ sky130_fd_sc_hd__nand2_1
X_05634_ _04974_ _04955_ _04975_ VSS VSS VDD VDD _04976_ sky130_fd_sc_hd__nand3_1
X_05635_ _04973_ _04976_ VSS VSS VDD VDD _04977_ sky130_fd_sc_hd__nand2_1
X_05636_ _04959_ _04977_ VSS VSS VDD VDD _04978_ sky130_fd_sc_hd__nand2_1
X_05637_ _04974_ _04956_ _04975_ VSS VSS VDD VDD _04979_ sky130_fd_sc_hd__nand3_1
X_05638_ _04970_ _04972_ _04955_ VSS VSS VDD VDD _04980_ sky130_fd_sc_hd__nand3_1
X_05639_ _04979_ _04980_ VSS VSS VDD VDD _04981_ sky130_fd_sc_hd__nand2_1
X_05640_ _04981_ _04958_ VSS VSS VDD VDD _04982_ sky130_fd_sc_hd__nand2_1
X_05641_ _04953_ _04948_ VSS VSS VDD VDD _04983_ sky130_fd_sc_hd__nand2_1
X_05642_ _04795_ _04983_ VSS VSS VDD VDD _04984_ sky130_fd_sc_hd__nor2_1
X_05643_ _04983_ _04795_ VSS VSS VDD VDD _04985_ sky130_fd_sc_hd__nand2_2
X_05644_ _04985_ VSS VSS VDD VDD _04986_ sky130_fd_sc_hd__inv_2
X_05645_ _04984_ _04986_ VSS VSS VDD VDD _04987_ sky130_fd_sc_hd__nor2_4
X_05646_ _04978_ _04982_ _04987_ VSS VSS VDD VDD _04988_ sky130_fd_sc_hd__nand3_1
X_05647_ _04959_ _04981_ VSS VSS VDD VDD _04989_ sky130_fd_sc_hd__nand2_1
X_05648_ _04977_ _04958_ VSS VSS VDD VDD _04990_ sky130_fd_sc_hd__nand2_1
X_05649_ _04987_ VSS VSS VDD VDD _04991_ sky130_fd_sc_hd__inv_2
X_05650_ _04989_ _04990_ _04991_ VSS VSS VDD VDD _04992_ sky130_fd_sc_hd__nand3_1
X_05651_ _04988_ _04992_ VSS VSS VDD VDD _04993_ sky130_fd_sc_hd__nand2_1
X_05652_ _04925_ _04924_ VSS VSS VDD VDD _04994_ sky130_fd_sc_hd__xor2_1
X_05653_ _04994_ _04922_ VSS VSS VDD VDD _04995_ sky130_fd_sc_hd__nand2_1
X_05654_ _04927_ _04926_ VSS VSS VDD VDD _04996_ sky130_fd_sc_hd__nand2_1
X_05655_ _04996_ _04921_ VSS VSS VDD VDD _04997_ sky130_fd_sc_hd__nand2_1
X_05656_ _04995_ _04997_ VSS VSS VDD VDD _04998_ sky130_fd_sc_hd__nand2_1
X_05657_ wrapped_design.a10_right\[3\] VSS VSS VDD VDD _04999_
+ sky130_fd_sc_hd__inv_1
X_05658_ _04999_ wrapped_design.b01_down\[7\] wrapped_design.b01_down\[6\]
+ wrapped_design.a10_right\[4\] VSS VSS VDD VDD _05000_ sky130_fd_sc_hd__nand4_4
X_05659_ wrapped_design.b01_down\[6\] wrapped_design.a10_right\[4\]
+ VSS VSS VDD VDD _05001_ sky130_fd_sc_hd__nand2_2
X_05660_ wrapped_design.a10_right\[3\] _04672_ _05001_ VSS
+ VSS VDD VDD _05002_ sky130_fd_sc_hd__o21ai_2
X_05661_ wrapped_design.b01_down\[5\] wrapped_design.a10_right\[5\]
+ VSS VSS VDD VDD _05003_ sky130_fd_sc_hd__nand2_1
X_05662_ _05003_ VSS VSS VDD VDD _05004_ sky130_fd_sc_hd__inv_1
X_05663_ _05000_ _05002_ _05004_ VSS VSS VDD VDD _05005_ sky130_fd_sc_hd__nand3_2
X_05664_ _05005_ _05000_ VSS VSS VDD VDD _05006_ sky130_fd_sc_hd__nand2_2
X_05665_ _05006_ VSS VSS VDD VDD _05007_ sky130_fd_sc_hd__inv_2
X_05666_ _04998_ _05007_ VSS VSS VDD VDD _05008_ sky130_fd_sc_hd__nand2_2
X_05667_ _04994_ _04921_ VSS VSS VDD VDD _05009_ sky130_fd_sc_hd__nand2_1
X_05668_ _04996_ _04922_ VSS VSS VDD VDD _05010_ sky130_fd_sc_hd__nand2_1
X_05669_ _05009_ _05010_ VSS VSS VDD VDD _05011_ sky130_fd_sc_hd__nand2_1
X_05670_ _05011_ _05006_ VSS VSS VDD VDD _05012_ sky130_fd_sc_hd__nand2_2
X_05671_ _05008_ _05012_ _04956_ VSS VSS VDD VDD _05013_ sky130_fd_sc_hd__nand3_1
X_05672_ _05013_ _05012_ VSS VSS VDD VDD _05014_ sky130_fd_sc_hd__nand2_1
X_05673_ _04929_ _04942_ VSS VSS VDD VDD _05015_ sky130_fd_sc_hd__nand2_1
X_05674_ _04943_ _04928_ VSS VSS VDD VDD _05016_ sky130_fd_sc_hd__nand2_1
X_05675_ _05015_ _05016_ _04956_ VSS VSS VDD VDD _05017_ sky130_fd_sc_hd__nand3_1
X_05676_ _04944_ _04945_ _04955_ VSS VSS VDD VDD _05018_ sky130_fd_sc_hd__nand3_1
X_05677_ _05017_ _05018_ VSS VSS VDD VDD _05019_ sky130_fd_sc_hd__nand2_1
X_05678_ _05014_ _05019_ VSS VSS VDD VDD _05020_ sky130_fd_sc_hd__nand2_1
X_05679_ _04956_ _05008_ _05012_ VSS VSS VDD VDD _05021_ sky130_fd_sc_hd__a21boi_2
X_05680_ _05015_ _05016_ _04955_ VSS VSS VDD VDD _05022_ sky130_fd_sc_hd__nand3_1
X_05681_ _05022_ _04957_ VSS VSS VDD VDD _05023_ sky130_fd_sc_hd__nand2_1
X_05682_ _05021_ _05023_ VSS VSS VDD VDD _05024_ sky130_fd_sc_hd__nand2_1
X_05683_ _05020_ _05024_ _04987_ VSS VSS VDD VDD _05025_ sky130_fd_sc_hd__nand3_1
X_05684_ _05025_ _05020_ VSS VSS VDD VDD _05026_ sky130_fd_sc_hd__nand2_1
X_05685_ _04993_ _05026_ VSS VSS VDD VDD _05027_ sky130_fd_sc_hd__nand2_1
X_05686_ _04989_ _04990_ _04987_ VSS VSS VDD VDD _05028_ sky130_fd_sc_hd__nand3_1
X_05687_ _04978_ _04982_ _04991_ VSS VSS VDD VDD _05029_ sky130_fd_sc_hd__nand3_1
X_05688_ _05028_ _05029_ VSS VSS VDD VDD _05030_ sky130_fd_sc_hd__nand2_1
X_05689_ _04987_ _05024_ _05020_ VSS VSS VDD VDD _05031_ sky130_fd_sc_hd__a21boi_1
X_05690_ _05030_ _05031_ VSS VSS VDD VDD _05032_ sky130_fd_sc_hd__nand2_1
X_05691_ _05027_ _05032_ _04986_ VSS VSS VDD VDD _05033_ sky130_fd_sc_hd__nand3_1
X_05692_ _05030_ _05026_ VSS VSS VDD VDD _05034_ sky130_fd_sc_hd__nand2_1
X_05693_ _04993_ _05031_ VSS VSS VDD VDD _05035_ sky130_fd_sc_hd__nand2_1
X_05694_ _05034_ _05035_ _04985_ VSS VSS VDD VDD _05036_ sky130_fd_sc_hd__nand3_1
X_05695_ _05033_ _05036_ VSS VSS VDD VDD _05037_ sky130_fd_sc_hd__nand2_1
X_05696_ _04947_ _04856_ VSS VSS VDD VDD _05038_ sky130_fd_sc_hd__nand2_1
X_05697_ _04946_ _04855_ VSS VSS VDD VDD _05039_ sky130_fd_sc_hd__nand2_1
X_05698_ _05038_ _04864_ _05039_ VSS VSS VDD VDD _05040_ sky130_fd_sc_hd__nand3_1
X_05699_ _05040_ _05038_ VSS VSS VDD VDD _05041_ sky130_fd_sc_hd__nand2_1
X_05700_ _05041_ VSS VSS VDD VDD _05042_ sky130_fd_sc_hd__inv_1
X_05701_ _04880_ _05042_ VSS VSS VDD VDD _05043_ sky130_fd_sc_hd__nor2_2
X_05702_ _05043_ VSS VSS VDD VDD _05044_ sky130_fd_sc_hd__inv_1
X_05703_ _05042_ _04880_ VSS VSS VDD VDD _05045_ sky130_fd_sc_hd__nand2_1
X_05704_ _05044_ _05045_ VSS VSS VDD VDD _05046_ sky130_fd_sc_hd__nand2_1
X_05705_ _05046_ VSS VSS VDD VDD _05047_ sky130_fd_sc_hd__inv_2
X_05706_ _05011_ _05007_ VSS VSS VDD VDD _05048_ sky130_fd_sc_hd__nand2_1
X_05707_ _04998_ _05006_ VSS VSS VDD VDD _05049_ sky130_fd_sc_hd__nand2_1
X_05708_ _05048_ _05049_ _04955_ VSS VSS VDD VDD _05050_ sky130_fd_sc_hd__nand3_1
X_05709_ _05013_ _05050_ VSS VSS VDD VDD _05051_ sky130_fd_sc_hd__nand2_1
X_05710_ _05038_ _05039_ VSS VSS VDD VDD _05052_ sky130_fd_sc_hd__nand2_1
X_05711_ _05052_ _04862_ VSS VSS VDD VDD _05053_ sky130_fd_sc_hd__nand2_1
X_05712_ _05053_ _05040_ VSS VSS VDD VDD _05054_ sky130_fd_sc_hd__nand2_1
X_05713_ _05054_ VSS VSS VDD VDD _05055_ sky130_fd_sc_hd__inv_1
X_05714_ _05000_ _05002_ VSS VSS VDD VDD _05056_ sky130_fd_sc_hd__nand2_1
X_05715_ _05056_ _05003_ VSS VSS VDD VDD _05057_ sky130_fd_sc_hd__nand2_1
X_05716_ _05057_ _05005_ VSS VSS VDD VDD _05058_ sky130_fd_sc_hd__nand2_1
X_05717_ _04847_ _04843_ _04841_ VSS VSS VDD VDD _05059_ sky130_fd_sc_hd__a21boi_1
X_05718_ _05058_ _05059_ VSS VSS VDD VDD _05060_ sky130_fd_sc_hd__nand2_2
X_05719_ _05056_ _05004_ VSS VSS VDD VDD _05061_ sky130_fd_sc_hd__nand2_1
X_05720_ _05000_ _05002_ _05003_ VSS VSS VDD VDD _05062_ sky130_fd_sc_hd__nand3_1
X_05721_ _05061_ _05062_ VSS VSS VDD VDD _05063_ sky130_fd_sc_hd__nand2_1
X_05722_ _04848_ _04841_ VSS VSS VDD VDD _05064_ sky130_fd_sc_hd__nand2_1
X_05723_ _05063_ _05064_ VSS VSS VDD VDD _05065_ sky130_fd_sc_hd__nand2_2
X_05724_ _05055_ _05060_ _05065_ VSS VSS VDD VDD _05066_ sky130_fd_sc_hd__a21boi_4
X_05725_ _05051_ _05066_ VSS VSS VDD VDD _05067_ sky130_fd_sc_hd__nand2_2
X_05726_ _05066_ VSS VSS VDD VDD _05068_ sky130_fd_sc_hd__inv_2
X_05727_ _05048_ _05049_ _04956_ VSS VSS VDD VDD _05069_ sky130_fd_sc_hd__nand3_1
X_05728_ _05008_ _05012_ _04955_ VSS VSS VDD VDD _05070_ sky130_fd_sc_hd__nand3_1
X_05729_ _05069_ _05070_ VSS VSS VDD VDD _05071_ sky130_fd_sc_hd__nand2_1
X_05730_ _05068_ _05071_ VSS VSS VDD VDD _05072_ sky130_fd_sc_hd__nand2_2
X_05731_ _05047_ _05067_ _05072_ VSS VSS VDD VDD _05073_ sky130_fd_sc_hd__a21boi_2
X_05732_ _05014_ _05023_ VSS VSS VDD VDD _05074_ sky130_fd_sc_hd__nand2_1
X_05733_ _05021_ _05019_ VSS VSS VDD VDD _05075_ sky130_fd_sc_hd__nand2_1
X_05734_ _05074_ _05075_ _04991_ VSS VSS VDD VDD _05076_ sky130_fd_sc_hd__nand3_1
X_05735_ _05025_ _05076_ VSS VSS VDD VDD _05077_ sky130_fd_sc_hd__nand2_1
X_05736_ _05073_ _05077_ VSS VSS VDD VDD _05078_ sky130_fd_sc_hd__nand2_2
X_05737_ _05074_ _05075_ _04987_ VSS VSS VDD VDD _05079_ sky130_fd_sc_hd__nand3_1
X_05738_ _05020_ _05024_ _04991_ VSS VSS VDD VDD _05080_ sky130_fd_sc_hd__nand3_1
X_05739_ _05079_ _05080_ VSS VSS VDD VDD _05081_ sky130_fd_sc_hd__nand2_1
X_05740_ _05072_ _05067_ _05047_ VSS VSS VDD VDD _05082_ sky130_fd_sc_hd__nand3_2
X_05741_ _05082_ _05072_ VSS VSS VDD VDD _05083_ sky130_fd_sc_hd__nand2_1
X_05742_ _05081_ _05083_ VSS VSS VDD VDD _05084_ sky130_fd_sc_hd__nand2_2
X_05743_ _05043_ _05078_ _05084_ VSS VSS VDD VDD _05085_ sky130_fd_sc_hd__a21boi_2
X_05744_ _05037_ _05085_ VSS VSS VDD VDD _05086_ sky130_fd_sc_hd__nand2_1
X_05745_ _05034_ _05035_ _04986_ VSS VSS VDD VDD _05087_ sky130_fd_sc_hd__nand3_1
X_05746_ _05027_ _05032_ _04985_ VSS VSS VDD VDD _05088_ sky130_fd_sc_hd__nand3_1
X_05747_ _05087_ _05088_ VSS VSS VDD VDD _05089_ sky130_fd_sc_hd__nand2_1
X_05748_ _05078_ _05084_ _05043_ VSS VSS VDD VDD _05090_ sky130_fd_sc_hd__nand3_2
X_05749_ _05090_ _05084_ VSS VSS VDD VDD _05091_ sky130_fd_sc_hd__nand2_1
X_05750_ _05089_ _05091_ VSS VSS VDD VDD _05092_ sky130_fd_sc_hd__nand2_1
X_05751_ _05086_ _05092_ VSS VSS VDD VDD _05093_ sky130_fd_sc_hd__nand2_1
X_05752_ _05073_ _05081_ VSS VSS VDD VDD _05094_ sky130_fd_sc_hd__nand2_1
X_05753_ _05077_ _05083_ VSS VSS VDD VDD _05095_ sky130_fd_sc_hd__nand2_1
X_05754_ _05094_ _05095_ _05043_ VSS VSS VDD VDD _05096_ sky130_fd_sc_hd__nand3_1
X_05755_ _05078_ _05084_ _05044_ VSS VSS VDD VDD _05097_ sky130_fd_sc_hd__nand3_1
X_05756_ _05096_ _05097_ VSS VSS VDD VDD _05098_ sky130_fd_sc_hd__nand2_1
X_05757_ _04864_ _04860_ _04857_ VSS VSS VDD VDD _05099_ sky130_fd_sc_hd__a21boi_1
X_05758_ _04880_ _05099_ VSS VSS VDD VDD _05100_ sky130_fd_sc_hd__nor2_2
X_05759_ _05068_ _05051_ VSS VSS VDD VDD _05101_ sky130_fd_sc_hd__nand2_1
X_05760_ _05071_ _05066_ VSS VSS VDD VDD _05102_ sky130_fd_sc_hd__nand2_1
X_05761_ _05101_ _05102_ _05046_ VSS VSS VDD VDD _05103_ sky130_fd_sc_hd__nand3_1
X_05762_ _05082_ _05103_ VSS VSS VDD VDD _05104_ sky130_fd_sc_hd__nand2_1
X_05763_ _05099_ _04880_ VSS VSS VDD VDD _05105_ sky130_fd_sc_hd__nand2_1
X_05764_ _05105_ VSS VSS VDD VDD _05106_ sky130_fd_sc_hd__inv_1
X_05765_ _05100_ _05106_ VSS VSS VDD VDD _05107_ sky130_fd_sc_hd__nor2_1
X_05766_ _05060_ _05065_ _05055_ VSS VSS VDD VDD _05108_ sky130_fd_sc_hd__nand3_1
X_05767_ _05063_ _05059_ VSS VSS VDD VDD _05109_ sky130_fd_sc_hd__nand2_1
X_05768_ _05058_ _05064_ VSS VSS VDD VDD _05110_ sky130_fd_sc_hd__nand2_1
X_05769_ _05109_ _05110_ _05054_ VSS VSS VDD VDD _05111_ sky130_fd_sc_hd__nand3_1
X_05770_ _05108_ _05111_ VSS VSS VDD VDD _05112_ sky130_fd_sc_hd__nand2_1
X_05771_ _04867_ _04850_ _04854_ VSS VSS VDD VDD _05113_ sky130_fd_sc_hd__a21boi_1
X_05772_ _05112_ _05113_ VSS VSS VDD VDD _05114_ sky130_fd_sc_hd__nand2_1
X_05773_ _05109_ _05110_ _05055_ VSS VSS VDD VDD _05115_ sky130_fd_sc_hd__nand3_1
X_05774_ _05060_ _05065_ _05054_ VSS VSS VDD VDD _05116_ sky130_fd_sc_hd__nand3_1
X_05775_ _05115_ _05116_ VSS VSS VDD VDD _05117_ sky130_fd_sc_hd__nand2_1
X_05776_ _04868_ _04854_ VSS VSS VDD VDD _05118_ sky130_fd_sc_hd__nand2_1
X_05777_ _05117_ _05118_ VSS VSS VDD VDD _05119_ sky130_fd_sc_hd__nand2_1
X_05778_ _05107_ _05114_ _05119_ VSS VSS VDD VDD _05120_ sky130_fd_sc_hd__a21boi_2
X_05779_ _05104_ _05120_ VSS VSS VDD VDD _05121_ sky130_fd_sc_hd__nand2_1
X_05780_ _05101_ _05102_ _05047_ VSS VSS VDD VDD _05122_ sky130_fd_sc_hd__nand3_1
X_05781_ _05072_ _05067_ _05046_ VSS VSS VDD VDD _00152_ sky130_fd_sc_hd__nand3_1
X_05782_ _05122_ _00152_ VSS VSS VDD VDD _00153_ sky130_fd_sc_hd__nand2_1
X_05783_ _05114_ _05119_ _05107_ VSS VSS VDD VDD _00154_ sky130_fd_sc_hd__nand3_1
X_05784_ _00154_ _05119_ VSS VSS VDD VDD _00155_ sky130_fd_sc_hd__nand2_1
X_05785_ _00153_ _00155_ VSS VSS VDD VDD _00156_ sky130_fd_sc_hd__nand2_1
X_05786_ _05100_ _05121_ _00156_ VSS VSS VDD VDD _00157_ sky130_fd_sc_hd__a21boi_2
X_05787_ _05098_ _00157_ VSS VSS VDD VDD _00158_ sky130_fd_sc_hd__nand2_1
X_05788_ _05094_ _05095_ _05044_ VSS VSS VDD VDD _00159_ sky130_fd_sc_hd__nand3_1
X_05789_ _05090_ _00159_ VSS VSS VDD VDD _00160_ sky130_fd_sc_hd__nand2_1
X_05790_ _00156_ _05121_ _05100_ VSS VSS VDD VDD _00161_ sky130_fd_sc_hd__nand3_1
X_05791_ _00161_ _00156_ VSS VSS VDD VDD _00162_ sky130_fd_sc_hd__nand2_1
X_05792_ _00160_ _00162_ VSS VSS VDD VDD _00163_ sky130_fd_sc_hd__nand2_1
X_05793_ _00158_ _00163_ VSS VSS VDD VDD _00164_ sky130_fd_sc_hd__nand2_1
X_05794_ _05093_ _00164_ VSS VSS VDD VDD _00165_ sky130_fd_sc_hd__nand2_1
X_05795_ _04887_ _04874_ _04879_ VSS VSS VDD VDD _00166_ sky130_fd_sc_hd__a21boi_2
X_05796_ _00166_ VSS VSS VDD VDD _00167_ sky130_fd_sc_hd__inv_2
X_05797_ _05117_ _05113_ VSS VSS VDD VDD _00168_ sky130_fd_sc_hd__nand2_1
X_05798_ _05112_ _05118_ VSS VSS VDD VDD _00169_ sky130_fd_sc_hd__nand2_1
X_05799_ _05107_ VSS VSS VDD VDD _00170_ sky130_fd_sc_hd__inv_1
X_05800_ _00168_ _00169_ _00170_ VSS VSS VDD VDD _00171_ sky130_fd_sc_hd__nand3_1
X_05801_ _00154_ _00171_ VSS VSS VDD VDD _00172_ sky130_fd_sc_hd__nand2_1
X_05802_ _00167_ _00172_ VSS VSS VDD VDD _00173_ sky130_fd_sc_hd__nand2_1
X_05803_ _00168_ _00169_ _05107_ VSS VSS VDD VDD _00174_ sky130_fd_sc_hd__nand3_1
X_05804_ _05114_ _05119_ _00170_ VSS VSS VDD VDD _00175_ sky130_fd_sc_hd__nand3_1
X_05805_ _00174_ _00175_ VSS VSS VDD VDD _00176_ sky130_fd_sc_hd__nand2_1
X_05806_ _00176_ _00166_ VSS VSS VDD VDD _00177_ sky130_fd_sc_hd__nand2_1
X_05807_ _00173_ _00177_ _04883_ VSS VSS VDD VDD _00178_ sky130_fd_sc_hd__nand3_1
X_05808_ _00167_ _00176_ VSS VSS VDD VDD _00179_ sky130_fd_sc_hd__nand2_2
X_05809_ _00172_ _00166_ VSS VSS VDD VDD _00180_ sky130_fd_sc_hd__nand2_1
X_05810_ _00179_ _00180_ _04884_ VSS VSS VDD VDD _00181_ sky130_fd_sc_hd__nand3_1
X_05811_ _00178_ _00181_ VSS VSS VDD VDD _00182_ sky130_fd_sc_hd__nand2_1
X_05812_ _04902_ _04899_ VSS VSS VDD VDD _00183_ sky130_fd_sc_hd__nand2_1
X_05813_ _00182_ _00183_ VSS VSS VDD VDD _00184_ sky130_fd_sc_hd__nand2_1
X_05814_ _00179_ _00180_ _04883_ VSS VSS VDD VDD _00185_ sky130_fd_sc_hd__nand3_1
X_05815_ _00173_ _00177_ _04884_ VSS VSS VDD VDD _00186_ sky130_fd_sc_hd__nand3_1
X_05816_ _00185_ _00186_ VSS VSS VDD VDD _00187_ sky130_fd_sc_hd__nand2_1
X_05817_ _04901_ _04894_ _04899_ VSS VSS VDD VDD _00188_ sky130_fd_sc_hd__a21boi_1
X_05818_ _00187_ _00188_ VSS VSS VDD VDD _00189_ sky130_fd_sc_hd__nand2_1
X_05819_ _00184_ _00189_ VSS VSS VDD VDD _00190_ sky130_fd_sc_hd__nand2_1
X_05820_ _00190_ VSS VSS VDD VDD _00191_ sky130_fd_sc_hd__inv_1
X_05821_ _05104_ _00155_ VSS VSS VDD VDD _00192_ sky130_fd_sc_hd__nand2_1
X_05822_ _00153_ _05120_ VSS VSS VDD VDD _00193_ sky130_fd_sc_hd__nand2_1
X_05823_ _00192_ _00193_ _05100_ VSS VSS VDD VDD _00194_ sky130_fd_sc_hd__nand3_1
X_05824_ _05100_ VSS VSS VDD VDD _00195_ sky130_fd_sc_hd__inv_1
X_05825_ _00156_ _05121_ _00195_ VSS VSS VDD VDD _00196_ sky130_fd_sc_hd__nand3_1
X_05826_ _00194_ _00196_ VSS VSS VDD VDD _00197_ sky130_fd_sc_hd__nand2_1
X_05827_ _04883_ _00180_ _00179_ VSS VSS VDD VDD _00198_ sky130_fd_sc_hd__a21boi_2
X_05828_ _00197_ _00198_ VSS VSS VDD VDD _00199_ sky130_fd_sc_hd__nand2_1
X_05829_ _00192_ _00193_ _00195_ VSS VSS VDD VDD _00200_ sky130_fd_sc_hd__nand3_1
X_05830_ _00161_ _00200_ VSS VSS VDD VDD _00201_ sky130_fd_sc_hd__nand2_1
X_05831_ _00185_ _00179_ VSS VSS VDD VDD _00202_ sky130_fd_sc_hd__nand2_1
X_05832_ _00201_ _00202_ VSS VSS VDD VDD _00203_ sky130_fd_sc_hd__nand2_1
X_05833_ _00199_ _00203_ VSS VSS VDD VDD _00204_ sky130_fd_sc_hd__nand2_1
X_05834_ _00191_ _00204_ VSS VSS VDD VDD _00205_ sky130_fd_sc_hd__nand2_1
X_05835_ _00165_ _00205_ VSS VSS VDD VDD _00206_ sky130_fd_sc_hd__nor2_1
X_05836_ _04920_ _00206_ VSS VSS VDD VDD _00207_ sky130_fd_sc_hd__nand2_1
X_05837_ _00197_ _00202_ VSS VSS VDD VDD _00208_ sky130_fd_sc_hd__nand2_1
X_05838_ _00208_ _00184_ VSS VSS VDD VDD _00209_ sky130_fd_sc_hd__nand2_1
X_05839_ _00201_ _00198_ VSS VSS VDD VDD _00210_ sky130_fd_sc_hd__nand2_1
X_05840_ _00209_ _00210_ VSS VSS VDD VDD _00211_ sky130_fd_sc_hd__nand2_1
X_05841_ _00211_ _00165_ VSS VSS VDD VDD _00212_ sky130_fd_sc_hd__nor2_1
X_05842_ _00157_ _00160_ VSS VSS VDD VDD _00213_ sky130_fd_sc_hd__nor2_1
X_05843_ _00213_ VSS VSS VDD VDD _00214_ sky130_fd_sc_hd__inv_1
X_05844_ _05089_ _05085_ VSS VSS VDD VDD _00215_ sky130_fd_sc_hd__nand2_1
X_05845_ _05037_ _05091_ VSS VSS VDD VDD _00216_ sky130_fd_sc_hd__nand2_1
X_05846_ _00215_ _00216_ VSS VSS VDD VDD _00217_ sky130_fd_sc_hd__nand2_2
X_05847_ _00214_ _00217_ _00216_ VSS VSS VDD VDD _00218_ sky130_fd_sc_hd__o21ai_0
X_05848_ _00212_ _00218_ VSS VSS VDD VDD _00219_ sky130_fd_sc_hd__nor2_1
X_05849_ _00207_ _00219_ VSS VSS VDD VDD _00220_ sky130_fd_sc_hd__nand2_1
X_05850_ _04988_ _04982_ VSS VSS VDD VDD _00221_ sky130_fd_sc_hd__nand2_1
X_05851_ _04973_ _04970_ VSS VSS VDD VDD _00222_ sky130_fd_sc_hd__nand2_1
X_05852_ _00222_ VSS VSS VDD VDD _00223_ sky130_fd_sc_hd__inv_2
X_05853_ _04966_ _04961_ VSS VSS VDD VDD _00224_ sky130_fd_sc_hd__nand2_1
X_05854_ _04940_ wrapped_design.b01_down\[6\] VSS VSS VDD
+ VDD _00225_ sky130_fd_sc_hd__nand2_1
X_05855_ wrapped_design.a10_right\[7\] _04672_ _04962_ VSS
+ VSS VDD VDD _00226_ sky130_fd_sc_hd__o21ai_0
X_05856_ _04940_ _00226_ VSS VSS VDD VDD _00227_ sky130_fd_sc_hd__nor2_1
X_05857_ _00224_ _00225_ _00227_ VSS VSS VDD VDD _00228_ sky130_fd_sc_hd__a21oi_1
X_05858_ _00228_ VSS VSS VDD VDD _00229_ sky130_fd_sc_hd__inv_1
X_05859_ _00229_ _04955_ VSS VSS VDD VDD _00230_ sky130_fd_sc_hd__nand2_1
X_05860_ _00228_ _04956_ VSS VSS VDD VDD _00231_ sky130_fd_sc_hd__nand2_1
X_05861_ _00230_ _00231_ VSS VSS VDD VDD _00232_ sky130_fd_sc_hd__nand2_1
X_05862_ _00223_ _00232_ VSS VSS VDD VDD _00233_ sky130_fd_sc_hd__nand2_1
X_05863_ _00222_ _00231_ _00230_ VSS VSS VDD VDD _00234_ sky130_fd_sc_hd__nand3_1
X_05864_ _00233_ _00234_ VSS VSS VDD VDD _00235_ sky130_fd_sc_hd__nand2_1
X_05865_ _00235_ _04991_ VSS VSS VDD VDD _00236_ sky130_fd_sc_hd__nand2_1
X_05866_ _00233_ _00234_ _04987_ VSS VSS VDD VDD _00237_ sky130_fd_sc_hd__nand3_1
X_05867_ _00221_ _00236_ _00237_ VSS VSS VDD VDD _00238_ sky130_fd_sc_hd__nand3_1
X_05868_ _00221_ VSS VSS VDD VDD _00239_ sky130_fd_sc_hd__inv_1
X_05869_ _00236_ _00237_ VSS VSS VDD VDD _00240_ sky130_fd_sc_hd__nand2_1
X_05870_ _00239_ _00240_ VSS VSS VDD VDD _00241_ sky130_fd_sc_hd__nand2_1
X_05871_ _00238_ _00241_ VSS VSS VDD VDD _00242_ sky130_fd_sc_hd__nand2_1
X_05872_ _00242_ _04985_ VSS VSS VDD VDD _00243_ sky130_fd_sc_hd__nand2_1
X_05873_ _00238_ _00241_ _04986_ VSS VSS VDD VDD _00244_ sky130_fd_sc_hd__nand3_1
X_05874_ _00243_ _00244_ VSS VSS VDD VDD _00245_ sky130_fd_sc_hd__nand2_1
X_05875_ _05087_ _05034_ VSS VSS VDD VDD _00246_ sky130_fd_sc_hd__nand2_1
X_05876_ _00246_ VSS VSS VDD VDD _00247_ sky130_fd_sc_hd__inv_1
X_05877_ _00245_ _00247_ VSS VSS VDD VDD _00248_ sky130_fd_sc_hd__nand2_1
X_05878_ _00246_ _00243_ _00244_ VSS VSS VDD VDD _00249_ sky130_fd_sc_hd__nand3_1
X_05879_ _00248_ _00249_ VSS VSS VDD VDD _00250_ sky130_fd_sc_hd__nand2_2
X_05880_ _00220_ _00250_ VSS VSS VDD VDD _00251_ sky130_fd_sc_hd__nand2_1
X_05881_ _00250_ VSS VSS VDD VDD _00252_ sky130_fd_sc_hd__inv_1
X_05882_ _00207_ _00219_ _00252_ VSS VSS VDD VDD _00253_ sky130_fd_sc_hd__nand3_1
X_05883_ _00251_ _00253_ VSS VSS VDD VDD _00254_ sky130_fd_sc_hd__nand2_1
X_05884_ _00254_ net114 VSS VSS VDD VDD _00255_ sky130_fd_sc_hd__nand2_1
X_05885_ _04834_ _04830_ VSS VSS VDD VDD _00256_ sky130_fd_sc_hd__nand2_1
X_05886_ _04829_ _04835_ VSS VSS VDD VDD _00257_ sky130_fd_sc_hd__nand2_1
X_05887_ _00256_ _00257_ VSS VSS VDD VDD _00258_ sky130_fd_sc_hd__nand2_1
X_05888_ _04741_ _04743_ VSS VSS VDD VDD _00259_ sky130_fd_sc_hd__nand2_1
X_05889_ _04737_ _04740_ _04744_ VSS VSS VDD VDD _00260_ sky130_fd_sc_hd__nand3_1
X_05890_ _00259_ _00260_ VSS VSS VDD VDD _00261_ sky130_fd_sc_hd__nand2_1
X_05891_ _00258_ _04607_ _00261_ VSS VSS VDD VDD _00262_ sky130_fd_sc_hd__nand3_1
X_05892_ _04747_ VSS VSS VDD VDD _00263_ sky130_fd_sc_hd__inv_1
X_05893_ _00263_ _04836_ _04917_ VSS VSS VDD VDD _00264_ sky130_fd_sc_hd__a21oi_2
X_05894_ _00262_ _00264_ VSS VSS VDD VDD _00265_ sky130_fd_sc_hd__nand2_1
X_05895_ _04914_ _00190_ VSS VSS VDD VDD _00266_ sky130_fd_sc_hd__nor2_1
X_05896_ _00265_ _00266_ VSS VSS VDD VDD _00267_ sky130_fd_sc_hd__nand2_2
X_05897_ _04918_ _00189_ _00184_ VSS VSS VDD VDD _00268_ sky130_fd_sc_hd__a21boi_2
X_05898_ _00267_ _00268_ VSS VSS VDD VDD _00269_ sky130_fd_sc_hd__nand2_4
X_05899_ _00164_ _00204_ VSS VSS VDD VDD _00270_ sky130_fd_sc_hd__nand2_1
X_05900_ _00217_ _00250_ _00270_ VSS VSS VDD VDD _00271_ sky130_fd_sc_hd__nor3_2
X_05901_ _00269_ _00271_ VSS VSS VDD VDD _00272_ sky130_fd_sc_hd__nand2_4
X_05902_ _00217_ _00250_ VSS VSS VDD VDD _00273_ sky130_fd_sc_hd__nor2_2
X_05903_ _00162_ _05098_ VSS VSS VDD VDD _00274_ sky130_fd_sc_hd__nor2_1
X_05904_ _00208_ _00274_ _00214_ VSS VSS VDD VDD _00275_ sky130_fd_sc_hd__o21ai_1
X_05905_ _00248_ _05091_ _05037_ VSS VSS VDD VDD _00276_ sky130_fd_sc_hd__nand3_1
X_05906_ _00276_ _00249_ VSS VSS VDD VDD _00277_ sky130_fd_sc_hd__nand2_1
X_05907_ _00273_ _00275_ _00277_ VSS VSS VDD VDD _00278_ sky130_fd_sc_hd__a21oi_4
X_05908_ _00223_ _00232_ _04987_ VSS VSS VDD VDD _00279_ sky130_fd_sc_hd__nand3_1
X_05909_ _04987_ _00234_ _00279_ VSS VSS VDD VDD _00280_ sky130_fd_sc_hd__o21ai_0
X_05910_ _00230_ _00280_ VSS VSS VDD VDD _00281_ sky130_fd_sc_hd__xor2_1
X_05911_ _00238_ _04985_ VSS VSS VDD VDD _00282_ sky130_fd_sc_hd__nand2_1
X_05912_ _00241_ _04986_ VSS VSS VDD VDD _00283_ sky130_fd_sc_hd__nand2_1
X_05913_ _00282_ _00283_ VSS VSS VDD VDD _00284_ sky130_fd_sc_hd__nand2_1
X_05914_ _00281_ _00284_ VSS VSS VDD VDD _00285_ sky130_fd_sc_hd__xor2_1
X_05915_ _00285_ VSS VSS VDD VDD _00286_ sky130_fd_sc_hd__clkinv_1
X_05916_ _00272_ _00278_ net115 _00286_ VSS VSS VDD VDD _00287_
+ sky130_fd_sc_hd__nand4_1
X_05917_ _00255_ _00287_ VSS VSS VDD VDD _00288_ sky130_fd_sc_hd__nand2_1
X_05918_ _00272_ _00278_ _00286_ VSS VSS VDD VDD _00289_ sky130_fd_sc_hd__nand3_2
Xoutput106 net106 VSS VSS VDD VDD c10[7] sky130_fd_sc_hd__clkdlybuf4s50_1
X_05920_ net115 VSS VSS VDD VDD _00291_ sky130_fd_sc_hd__inv_1
X_05921_ _00289_ _00291_ VSS VSS VDD VDD _00292_ sky130_fd_sc_hd__nand2_4
X_05922_ _00288_ _00292_ VSS VSS VDD VDD _00293_ sky130_fd_sc_hd__nand2_1
X_05923_ _00293_ VSS VSS VDD VDD _00294_ sky130_fd_sc_hd__inv_1
X_05924_ net117 VSS VSS VDD VDD _00295_ sky130_fd_sc_hd__inv_1
X_05925_ _00289_ _00295_ VSS VSS VDD VDD _00296_ sky130_fd_sc_hd__nand2_2
X_05926_ _00272_ _00278_ net117 _00286_ VSS VSS VDD VDD _00297_
+ sky130_fd_sc_hd__nand4_1
X_05927_ _00296_ _00297_ VSS VSS VDD VDD _00298_ sky130_fd_sc_hd__nand2_2
X_05928_ net116 VSS VSS VDD VDD _00299_ sky130_fd_sc_hd__inv_1
X_05929_ _00289_ _00299_ VSS VSS VDD VDD _00300_ sky130_fd_sc_hd__nand2_1
X_05930_ _00272_ _00278_ net116 _00286_ VSS VSS VDD VDD _00301_
+ sky130_fd_sc_hd__nand4_1
X_05931_ _00300_ _00301_ VSS VSS VDD VDD _00302_ sky130_fd_sc_hd__nand2_1
X_05932_ _00298_ _00302_ VSS VSS VDD VDD _00303_ sky130_fd_sc_hd__nor2_1
X_05933_ _00294_ _00303_ VSS VSS VDD VDD _00304_ sky130_fd_sc_hd__nand2_1
X_05934_ _00297_ _00301_ VSS VSS VDD VDD _00305_ sky130_fd_sc_hd__nand2_1
X_05935_ _00305_ VSS VSS VDD VDD _00306_ sky130_fd_sc_hd__inv_1
X_05936_ _00304_ _00306_ VSS VSS VDD VDD _00307_ sky130_fd_sc_hd__nand2_1
X_05937_ net118 VSS VSS VDD VDD _00308_ sky130_fd_sc_hd__inv_1
X_05938_ _00289_ _00308_ VSS VSS VDD VDD _00309_ sky130_fd_sc_hd__nand2_2
X_05939_ _00272_ _00278_ net118 _00286_ VSS VSS VDD VDD _00310_
+ sky130_fd_sc_hd__nand4_1
X_05940_ _00309_ _00310_ VSS VSS VDD VDD _00311_ sky130_fd_sc_hd__nand2_2
X_05941_ _00311_ VSS VSS VDD VDD _00312_ sky130_fd_sc_hd__inv_1
X_05942_ net119 VSS VSS VDD VDD _00313_ sky130_fd_sc_hd__inv_1
X_05943_ _00289_ _00313_ VSS VSS VDD VDD _00314_ sky130_fd_sc_hd__nand2_1
X_05944_ _00272_ _00278_ net119 _00286_ VSS VSS VDD VDD _00315_
+ sky130_fd_sc_hd__nand4_1
X_05945_ _00314_ _00315_ VSS VSS VDD VDD _00316_ sky130_fd_sc_hd__nand2_2
X_05946_ _00316_ VSS VSS VDD VDD _00317_ sky130_fd_sc_hd__inv_1
X_05947_ _00312_ _00317_ VSS VSS VDD VDD _00318_ sky130_fd_sc_hd__nand2_1
X_05948_ net122 VSS VSS VDD VDD _00319_ sky130_fd_sc_hd__inv_1
X_05949_ _00289_ _00319_ VSS VSS VDD VDD _00320_ sky130_fd_sc_hd__nand2_1
X_05950_ _00272_ _00278_ net122 _00286_ VSS VSS VDD VDD _00321_
+ sky130_fd_sc_hd__nand4_1
X_05951_ _00320_ _00321_ VSS VSS VDD VDD _00322_ sky130_fd_sc_hd__nand2_1
X_05952_ _00322_ VSS VSS VDD VDD _00323_ sky130_fd_sc_hd__inv_1
X_05953_ net121 VSS VSS VDD VDD _00324_ sky130_fd_sc_hd__inv_1
X_05954_ _00289_ _00324_ VSS VSS VDD VDD _00325_ sky130_fd_sc_hd__nand2_2
X_05955_ _00272_ _00278_ net121 _00286_ VSS VSS VDD VDD _00326_
+ sky130_fd_sc_hd__nand4_1
X_05956_ _00325_ _00326_ VSS VSS VDD VDD _00327_ sky130_fd_sc_hd__nand2_2
X_05957_ _00327_ VSS VSS VDD VDD _00328_ sky130_fd_sc_hd__inv_1
X_05958_ _00323_ _00328_ VSS VSS VDD VDD _00329_ sky130_fd_sc_hd__nand2_1
X_05959_ _00318_ _00329_ VSS VSS VDD VDD _00330_ sky130_fd_sc_hd__nor2_1
X_05960_ _00289_ VSS VSS VDD VDD _00331_ sky130_fd_sc_hd__inv_2
X_05961_ net118 net119 net121 net122 _00331_ VSS VSS VDD VDD
+ _00332_ sky130_fd_sc_hd__o41ai_1
X_05962_ _00307_ _00330_ _00332_ VSS VSS VDD VDD _00333_ sky130_fd_sc_hd__a21boi_1
X_05963_ _00292_ _00287_ VSS VSS VDD VDD _00334_ sky130_fd_sc_hd__nand2_2
X_05964_ net114 VSS VSS VDD VDD _00335_ sky130_fd_sc_hd__inv_1
X_05965_ _00251_ _00253_ _00335_ VSS VSS VDD VDD _00336_ sky130_fd_sc_hd__nand3_1
X_05966_ _00255_ _00336_ VSS VSS VDD VDD _00337_ sky130_fd_sc_hd__nand2_1
X_05967_ _00334_ _00337_ VSS VSS VDD VDD _00338_ sky130_fd_sc_hd__nor2_1
X_05968_ _00338_ _00303_ VSS VSS VDD VDD _00339_ sky130_fd_sc_hd__nand2_1
X_05969_ _00329_ _00318_ _00339_ VSS VSS VDD VDD _00340_ sky130_fd_sc_hd__nor3_2
X_05970_ _04748_ _00258_ VSS VSS VDD VDD _00341_ sky130_fd_sc_hd__nand2_1
X_05971_ _04746_ _04747_ _04837_ VSS VSS VDD VDD _00342_ sky130_fd_sc_hd__nand3_1
X_05972_ _00341_ _00342_ VSS VSS VDD VDD _00343_ sky130_fd_sc_hd__nand2_1
X_05973_ net131 VSS VSS VDD VDD _00344_ sky130_fd_sc_hd__inv_1
X_05974_ _00343_ _00344_ VSS VSS VDD VDD _00345_ sky130_fd_sc_hd__nand2_1
X_05975_ _00341_ net131 _00342_ VSS VSS VDD VDD _00346_ sky130_fd_sc_hd__nand3_1
X_05976_ _00345_ _00346_ VSS VSS VDD VDD _00347_ sky130_fd_sc_hd__nand2_1
X_05977_ _00265_ _04914_ VSS VSS VDD VDD _00348_ sky130_fd_sc_hd__nand2_1
X_05978_ _04914_ _00262_ _00264_ VSS VSS VDD VDD _00349_ sky130_fd_sc_hd__nand3b_1
X_05979_ _00348_ _00349_ VSS VSS VDD VDD _00350_ sky130_fd_sc_hd__nand2_1
X_05980_ _00350_ net132 VSS VSS VDD VDD _00351_ sky130_fd_sc_hd__nand2_1
X_05981_ _03286_ _03242_ VSS VSS VDD VDD _00352_ sky130_fd_sc_hd__nand2_1
X_05982_ _03242_ _03275_ _03092_ VSS VSS VDD VDD _00353_ sky130_fd_sc_hd__nand3b_1
X_05983_ _00352_ _00353_ VSS VSS VDD VDD _00354_ sky130_fd_sc_hd__nand2_1
X_05984_ _00354_ VSS VSS VDD VDD _00355_ sky130_fd_sc_hd__inv_1
X_05985_ net127 _00355_ VSS VSS VDD VDD _00356_ sky130_fd_sc_hd__or2_2
X_05986_ net125 VSS VSS VDD VDD _00357_ sky130_fd_sc_hd__inv_1
X_05987_ _03186_ _02736_ VSS VSS VDD VDD _00358_ sky130_fd_sc_hd__nand2_1
X_05988_ _03201_ _00358_ VSS VSS VDD VDD _00359_ sky130_fd_sc_hd__nand2_1
X_05989_ net120 VSS VSS VDD VDD _00360_ sky130_fd_sc_hd__inv_1
X_05990_ wrapped_design.b01_down\[0\] wrapped_design.a10_right\[1\]
+ wrapped_design.b01_down\[1\] wrapped_design.a10_right\[0\]
+ VSS VSS VDD VDD _00361_ sky130_fd_sc_hd__a22o_1
X_05991_ _00361_ _03150_ VSS VSS VDD VDD _00362_ sky130_fd_sc_hd__nand2_1
X_05992_ _00360_ _00362_ VSS VSS VDD VDD _00363_ sky130_fd_sc_hd__nor2_1
X_05993_ net109 VSS VSS VDD VDD _00364_ sky130_fd_sc_hd__inv_1
X_05994_ _00364_ _03131_ VSS VSS VDD VDD _00365_ sky130_fd_sc_hd__nor2_1
X_05995_ _00365_ VSS VSS VDD VDD _00366_ sky130_fd_sc_hd__inv_1
X_05996_ _00363_ VSS VSS VDD VDD _00367_ sky130_fd_sc_hd__inv_1
X_05997_ _00362_ _00360_ VSS VSS VDD VDD _00368_ sky130_fd_sc_hd__nand2_1
X_05998_ _00367_ _00368_ VSS VSS VDD VDD _00369_ sky130_fd_sc_hd__nand2_1
X_05999_ _00366_ _00369_ VSS VSS VDD VDD _00370_ sky130_fd_sc_hd__nor2_1
X_06000_ _00357_ _00359_ VSS VSS VDD VDD _00371_ sky130_fd_sc_hd__nor2_1
X_06001_ _03201_ _00358_ net125 VSS VSS VDD VDD _00372_ sky130_fd_sc_hd__a21oi_1
X_06002_ _00371_ _00372_ VSS VSS VDD VDD _00373_ sky130_fd_sc_hd__nor2_1
X_06003_ _00363_ _00370_ _00373_ VSS VSS VDD VDD _00374_ sky130_fd_sc_hd__o21ai_0
X_06004_ _00357_ _00359_ _00374_ VSS VSS VDD VDD _00375_ sky130_fd_sc_hd__o21ai_0
X_06005_ net126 VSS VSS VDD VDD _00376_ sky130_fd_sc_hd__inv_1
X_06006_ _03073_ _03233_ VSS VSS VDD VDD _00377_ sky130_fd_sc_hd__nand2_1
X_06007_ _00377_ _03178_ _03201_ VSS VSS VDD VDD _00378_ sky130_fd_sc_hd__nand3_1
X_06008_ _00378_ _03242_ VSS VSS VDD VDD _00379_ sky130_fd_sc_hd__nand2_1
X_06009_ _00376_ _00379_ VSS VSS VDD VDD _00380_ sky130_fd_sc_hd__nor2_1
X_06010_ _00378_ _03242_ net126 VSS VSS VDD VDD _00381_ sky130_fd_sc_hd__a21oi_1
X_06011_ _00380_ _00381_ VSS VSS VDD VDD _00382_ sky130_fd_sc_hd__nor2_1
X_06012_ _00375_ _00382_ VSS VSS VDD VDD _00383_ sky130_fd_sc_hd__nand2_1
X_06013_ _00380_ VSS VSS VDD VDD _00384_ sky130_fd_sc_hd__inv_1
X_06014_ _00383_ _00384_ VSS VSS VDD VDD _00385_ sky130_fd_sc_hd__nand2_1
X_06015_ _00356_ _00385_ VSS VSS VDD VDD _00386_ sky130_fd_sc_hd__nand2_1
X_06016_ _00355_ net127 VSS VSS VDD VDD _00387_ sky130_fd_sc_hd__nand2_1
X_06017_ _00386_ _00387_ VSS VSS VDD VDD _00388_ sky130_fd_sc_hd__nand2_1
X_06018_ _03858_ _03092_ VSS VSS VDD VDD _00389_ sky130_fd_sc_hd__nand2_1
X_06019_ _03803_ _03847_ _03102_ VSS VSS VDD VDD _00390_ sky130_fd_sc_hd__nand3_1
X_06020_ _00389_ _00390_ VSS VSS VDD VDD _00391_ sky130_fd_sc_hd__nand2_1
X_06021_ _00391_ _00353_ VSS VSS VDD VDD _00392_ sky130_fd_sc_hd__nand2_1
X_06022_ _00389_ _00390_ _03297_ VSS VSS VDD VDD _00393_ sky130_fd_sc_hd__nand3_1
X_06023_ net128 VSS VSS VDD VDD _00394_ sky130_fd_sc_hd__inv_1
X_06024_ _00392_ _00393_ _00394_ VSS VSS VDD VDD _00395_ sky130_fd_sc_hd__nand3_1
X_06025_ _00388_ _00395_ VSS VSS VDD VDD _00396_ sky130_fd_sc_hd__nand2_1
X_06026_ _04490_ _04518_ _04564_ VSS VSS VDD VDD _00397_ sky130_fd_sc_hd__nand3_1
X_06027_ _04742_ _00397_ VSS VSS VDD VDD _00398_ sky130_fd_sc_hd__nand2_1
X_06028_ _03891_ VSS VSS VDD VDD _00399_ sky130_fd_sc_hd__inv_1
X_06029_ _00398_ _00399_ VSS VSS VDD VDD _00400_ sky130_fd_sc_hd__nand2_1
X_06030_ _04598_ _00400_ VSS VSS VDD VDD _00401_ sky130_fd_sc_hd__nand2_1
X_06031_ _00401_ _03869_ VSS VSS VDD VDD _00402_ sky130_fd_sc_hd__nand2_1
X_06032_ _03858_ _03102_ VSS VSS VDD VDD _00403_ sky130_fd_sc_hd__nand2_1
X_06033_ _03858_ _03297_ VSS VSS VDD VDD _00404_ sky130_fd_sc_hd__nand2_1
X_06034_ _00403_ _00404_ VSS VSS VDD VDD _00405_ sky130_fd_sc_hd__nand2_1
X_06035_ _00405_ _04598_ _00400_ VSS VSS VDD VDD _00406_ sky130_fd_sc_hd__nand3_1
X_06036_ _00402_ _00406_ net129 VSS VSS VDD VDD _00407_ sky130_fd_sc_hd__nand3_1
X_06037_ _00392_ _00393_ VSS VSS VDD VDD _00408_ sky130_fd_sc_hd__nand2_1
X_06038_ _00408_ net128 VSS VSS VDD VDD _00409_ sky130_fd_sc_hd__nand2_1
X_06039_ _00396_ _00407_ _00409_ VSS VSS VDD VDD _00410_ sky130_fd_sc_hd__nand3_1
X_06040_ _00405_ _00400_ _04598_ VSS VSS VDD VDD _00411_ sky130_fd_sc_hd__a21boi_0
X_06041_ _00411_ _00261_ VSS VSS VDD VDD _00412_ sky130_fd_sc_hd__nand2_1
X_06042_ _04745_ _04747_ VSS VSS VDD VDD _00413_ sky130_fd_sc_hd__nand2_1
X_06043_ _04607_ _00413_ VSS VSS VDD VDD _00414_ sky130_fd_sc_hd__nand2_1
X_06044_ net130 _00412_ _00414_ VSS VSS VDD VDD _00415_ sky130_fd_sc_hd__nand3b_1
X_06045_ _00406_ _00402_ net129 VSS VSS VDD VDD _00416_ sky130_fd_sc_hd__a21o_1
X_06046_ _00410_ _00415_ _00416_ VSS VSS VDD VDD _00417_ sky130_fd_sc_hd__nand3_1
X_06047_ _00412_ _00414_ VSS VSS VDD VDD _00418_ sky130_fd_sc_hd__nand2_1
X_06048_ _00418_ net130 VSS VSS VDD VDD _00419_ sky130_fd_sc_hd__nand2_1
X_06049_ _00417_ _00419_ VSS VSS VDD VDD _00420_ sky130_fd_sc_hd__nand2_1
X_06050_ net132 _00348_ _00349_ VSS VSS VDD VDD _00421_ sky130_fd_sc_hd__nand3b_1
X_06051_ _00351_ _00420_ _00421_ VSS VSS VDD VDD _00422_ sky130_fd_sc_hd__nand3_1
X_06052_ _00347_ _00422_ VSS VSS VDD VDD _00423_ sky130_fd_sc_hd__nor2_1
X_06053_ _00204_ VSS VSS VDD VDD _00424_ sky130_fd_sc_hd__inv_1
X_06054_ _00269_ _00424_ VSS VSS VDD VDD _00425_ sky130_fd_sc_hd__nand2_1
X_06055_ _00267_ _00204_ _00268_ VSS VSS VDD VDD _00426_ sky130_fd_sc_hd__nand3_1
X_06056_ _00425_ _00426_ net111 VSS VSS VDD VDD _00427_ sky130_fd_sc_hd__nand3_1
X_06057_ _00269_ _00204_ VSS VSS VDD VDD _00428_ sky130_fd_sc_hd__nand2_1
X_06058_ net111 VSS VSS VDD VDD _00429_ sky130_fd_sc_hd__inv_1
X_06059_ _00267_ _00424_ _00268_ VSS VSS VDD VDD _00430_ sky130_fd_sc_hd__nand3_1
X_06060_ _00428_ _00429_ _00430_ VSS VSS VDD VDD _00431_ sky130_fd_sc_hd__nand3_1
X_06061_ _00427_ _00431_ VSS VSS VDD VDD _00432_ sky130_fd_sc_hd__nand2_1
X_06062_ net110 _00190_ _04920_ VSS VSS VDD VDD _00433_ sky130_fd_sc_hd__xnor3_1
X_06063_ _00423_ _00432_ _00433_ VSS VSS VDD VDD _00434_ sky130_fd_sc_hd__nand3_1
X_06064_ _00425_ _00426_ VSS VSS VDD VDD _00435_ sky130_fd_sc_hd__nand2_1
X_06065_ _00435_ net111 VSS VSS VDD VDD _00436_ sky130_fd_sc_hd__nand2_1
X_06066_ _00191_ _04920_ VSS VSS VDD VDD _00437_ sky130_fd_sc_hd__xor2_1
X_06067_ _00437_ net110 VSS VSS VDD VDD _00438_ sky130_fd_sc_hd__nand2_1
X_06068_ _00436_ _00438_ VSS VSS VDD VDD _00439_ sky130_fd_sc_hd__nand2_1
X_06069_ net111 _00435_ _00439_ VSS VSS VDD VDD _00440_ sky130_fd_sc_hd__o21ai_0
X_06070_ _00421_ VSS VSS VDD VDD _00441_ sky130_fd_sc_hd__inv_1
X_06071_ _00351_ _00346_ _00441_ VSS VSS VDD VDD _00442_ sky130_fd_sc_hd__a21oi_1
X_06072_ _00432_ _00433_ _00442_ VSS VSS VDD VDD _00443_ sky130_fd_sc_hd__nand3_1
X_06073_ _00434_ _00440_ _00443_ VSS VSS VDD VDD _00444_ sky130_fd_sc_hd__nand3_1
X_06074_ _00205_ VSS VSS VDD VDD _00445_ sky130_fd_sc_hd__inv_1
X_06075_ _04920_ _00445_ VSS VSS VDD VDD _00446_ sky130_fd_sc_hd__nand2_1
X_06076_ _00446_ _00164_ _00211_ VSS VSS VDD VDD _00447_ sky130_fd_sc_hd__nand3_1
X_06077_ _04916_ _00211_ _04919_ VSS VSS VDD VDD _00448_ sky130_fd_sc_hd__nand3_1
X_06078_ _00164_ VSS VSS VDD VDD _00449_ sky130_fd_sc_hd__inv_1
X_06079_ _00205_ _00211_ VSS VSS VDD VDD _00450_ sky130_fd_sc_hd__nand2_1
X_06080_ _00448_ _00449_ _00450_ VSS VSS VDD VDD _00451_ sky130_fd_sc_hd__nand3_1
X_06081_ _00447_ _00451_ VSS VSS VDD VDD _00452_ sky130_fd_sc_hd__nand2_1
X_06082_ _00452_ net112 VSS VSS VDD VDD _00453_ sky130_fd_sc_hd__nand2_1
X_06083_ net112 VSS VSS VDD VDD _00454_ sky130_fd_sc_hd__inv_1
X_06084_ _00447_ _00454_ _00451_ VSS VSS VDD VDD _00455_ sky130_fd_sc_hd__nand3_1
X_06085_ _00453_ _00455_ VSS VSS VDD VDD _00456_ sky130_fd_sc_hd__nand2_1
X_06086_ _00270_ VSS VSS VDD VDD _00457_ sky130_fd_sc_hd__inv_1
X_06087_ _00269_ _00457_ VSS VSS VDD VDD _00458_ sky130_fd_sc_hd__nand2_1
X_06088_ _00275_ VSS VSS VDD VDD _00459_ sky130_fd_sc_hd__inv_1
X_06089_ _00458_ _00459_ VSS VSS VDD VDD _00460_ sky130_fd_sc_hd__nand2_1
X_06090_ _00460_ _05093_ VSS VSS VDD VDD _00461_ sky130_fd_sc_hd__nand2_1
X_06091_ _00458_ _00217_ _00459_ VSS VSS VDD VDD _00462_ sky130_fd_sc_hd__nand3_1
X_06092_ _00461_ _00462_ VSS VSS VDD VDD _00463_ sky130_fd_sc_hd__nand2_1
X_06093_ net113 VSS VSS VDD VDD _00464_ sky130_fd_sc_hd__inv_1
X_06094_ _00463_ _00464_ VSS VSS VDD VDD _00465_ sky130_fd_sc_hd__nand2_1
X_06095_ _00461_ net113 _00462_ VSS VSS VDD VDD _00466_ sky130_fd_sc_hd__nand3_1
X_06096_ _00465_ _00466_ VSS VSS VDD VDD _00467_ sky130_fd_sc_hd__nand2_1
X_06097_ _00456_ _00467_ VSS VSS VDD VDD _00468_ sky130_fd_sc_hd__nor2_1
X_06098_ _00444_ _00468_ VSS VSS VDD VDD _00469_ sky130_fd_sc_hd__nand2_1
X_06099_ _00466_ _00453_ VSS VSS VDD VDD _00470_ sky130_fd_sc_hd__nand2_1
X_06100_ _00470_ _00465_ VSS VSS VDD VDD _00471_ sky130_fd_sc_hd__nand2_1
X_06101_ _00469_ _00471_ VSS VSS VDD VDD _00472_ sky130_fd_sc_hd__nand2_1
X_06102_ _00340_ _00472_ VSS VSS VDD VDD _00473_ sky130_fd_sc_hd__nand2_1
X_06103_ _00333_ _00473_ VSS VSS VDD VDD _00474_ sky130_fd_sc_hd__nand2_1
X_06104_ net123 VSS VSS VDD VDD _00475_ sky130_fd_sc_hd__inv_1
X_06105_ _00289_ _00475_ VSS VSS VDD VDD _00476_ sky130_fd_sc_hd__nand2_1
X_06106_ _00272_ _00278_ net123 _00286_ VSS VSS VDD VDD _00477_
+ sky130_fd_sc_hd__nand4_1
X_06107_ _00476_ _00477_ VSS VSS VDD VDD _00478_ sky130_fd_sc_hd__nand2_1
X_06108_ _00478_ VSS VSS VDD VDD _00479_ sky130_fd_sc_hd__inv_1
X_06109_ _00474_ _00479_ VSS VSS VDD VDD _00480_ sky130_fd_sc_hd__nand2_1
Xoutput105 net105 VSS VSS VDD VDD c10[6] sky130_fd_sc_hd__clkdlybuf4s50_1
X_06111_ wrapped_design.pe10.start_out VSS VSS VDD VDD _00482_
+ sky130_fd_sc_hd__inv_1
Xoutput104 net104 VSS VSS VDD VDD c10[5] sky130_fd_sc_hd__clkdlybuf4s50_1
X_06113_ _00333_ _00473_ _00478_ VSS VSS VDD VDD _00484_ sky130_fd_sc_hd__nand3_1
X_06114_ _00480_ _00482_ _00484_ VSS VSS VDD VDD _00485_ sky130_fd_sc_hd__nand3_1
X_06115_ net155 VSS VSS VDD VDD _00486_ sky130_fd_sc_hd__inv_1
X_06116_ _00289_ net155 VSS VSS VDD VDD _00487_ sky130_fd_sc_hd__nand2_1
X_06117_ _00486_ wrapped_design.pe10.start_out _00487_ VSS
+ VSS VDD VDD _00488_ sky130_fd_sc_hd__o21ai_1
Xoutput103 net103 VSS VSS VDD VDD c10[4] sky130_fd_sc_hd__clkdlybuf4s50_1
Xoutput102 net102 VSS VSS VDD VDD c10[3] sky130_fd_sc_hd__clkdlybuf4s50_1
X_06120_ net34 VSS VSS VDD VDD _00491_ sky130_fd_sc_hd__inv_1
Xoutput101 net101 VSS VSS VDD VDD c10[2] sky130_fd_sc_hd__clkdlybuf4s50_1
X_06122_ net155 net123 _00491_ VSS VSS VDD VDD _00493_ sky130_fd_sc_hd__o21ai_0
X_06123_ _00485_ _00488_ _00493_ VSS VSS VDD VDD _00000_ sky130_fd_sc_hd__a21oi_1
X_06124_ _00432_ VSS VSS VDD VDD _00494_ sky130_fd_sc_hd__inv_1
X_06125_ _00494_ _00456_ VSS VSS VDD VDD _00495_ sky130_fd_sc_hd__nor2_1
X_06126_ _00351_ VSS VSS VDD VDD _00496_ sky130_fd_sc_hd__inv_1
X_06127_ _00441_ _00496_ VSS VSS VDD VDD _00497_ sky130_fd_sc_hd__nor2_1
X_06128_ _00420_ _00345_ VSS VSS VDD VDD _00498_ sky130_fd_sc_hd__nand2_1
X_06129_ _00498_ _00346_ VSS VSS VDD VDD _00499_ sky130_fd_sc_hd__nand2_1
X_06130_ _00497_ _00499_ VSS VSS VDD VDD _00500_ sky130_fd_sc_hd__nand2_1
X_06131_ _00500_ _00438_ _00351_ VSS VSS VDD VDD _00501_ sky130_fd_sc_hd__nand3_1
X_06132_ net110 _00437_ VSS VSS VDD VDD _00502_ sky130_fd_sc_hd__nor2_1
X_06133_ _00502_ VSS VSS VDD VDD _00503_ sky130_fd_sc_hd__inv_1
X_06134_ _00495_ _00501_ _00503_ VSS VSS VDD VDD _00504_ sky130_fd_sc_hd__nand3_1
X_06135_ _00453_ _00436_ VSS VSS VDD VDD _00505_ sky130_fd_sc_hd__nand2_1
X_06136_ _00505_ _00455_ VSS VSS VDD VDD _00506_ sky130_fd_sc_hd__nand2_1
X_06137_ _00504_ _00506_ VSS VSS VDD VDD _00507_ sky130_fd_sc_hd__nand2_1
X_06138_ _00302_ _00334_ VSS VSS VDD VDD _00508_ sky130_fd_sc_hd__nor2_4
X_06139_ _00508_ VSS VSS VDD VDD _00509_ sky130_fd_sc_hd__inv_1
X_06140_ _00337_ VSS VSS VDD VDD _00510_ sky130_fd_sc_hd__inv_1
X_06141_ _00510_ _00465_ _00466_ VSS VSS VDD VDD _00511_ sky130_fd_sc_hd__nand3_1
X_06142_ _00509_ _00511_ VSS VSS VDD VDD _00512_ sky130_fd_sc_hd__nor2_1
X_06143_ _00327_ _00316_ VSS VSS VDD VDD _00513_ sky130_fd_sc_hd__nor2_1
X_06144_ _00311_ _00298_ VSS VSS VDD VDD _00514_ sky130_fd_sc_hd__nor2_2
X_06145_ _00513_ _00514_ VSS VSS VDD VDD _00515_ sky130_fd_sc_hd__and2_1
X_06146_ _00507_ _00512_ _00515_ VSS VSS VDD VDD _00516_ sky130_fd_sc_hd__nand3_1
X_06147_ _00460_ _00217_ VSS VSS VDD VDD _00517_ sky130_fd_sc_hd__nand2_1
X_06148_ _00458_ _05093_ _00459_ VSS VSS VDD VDD _00518_ sky130_fd_sc_hd__nand3_1
X_06149_ _00517_ _00518_ VSS VSS VDD VDD _00519_ sky130_fd_sc_hd__nand2_1
X_06150_ _00519_ _00336_ net113 VSS VSS VDD VDD _00520_ sky130_fd_sc_hd__nand3_1
X_06151_ _00520_ _00255_ VSS VSS VDD VDD _00521_ sky130_fd_sc_hd__nand2_1
X_06152_ _00521_ _00508_ VSS VSS VDD VDD _00522_ sky130_fd_sc_hd__nand2_1
X_06153_ net115 net116 _00331_ VSS VSS VDD VDD _00523_ sky130_fd_sc_hd__o21ai_0
X_06154_ _00522_ _00523_ VSS VSS VDD VDD _00524_ sky130_fd_sc_hd__nand2_1
X_06155_ _00524_ _00515_ VSS VSS VDD VDD _00525_ sky130_fd_sc_hd__nand2_1
X_06156_ net117 net118 net119 net121 _00331_ VSS VSS VDD VDD
+ _00526_ sky130_fd_sc_hd__o41ai_1
X_06157_ _00516_ _00525_ _00526_ VSS VSS VDD VDD _00527_ sky130_fd_sc_hd__nand3_1
X_06158_ _00527_ _00323_ VSS VSS VDD VDD _00528_ sky130_fd_sc_hd__nand2_1
X_06159_ _00516_ _00322_ _00525_ _00526_ VSS VSS VDD VDD _00529_
+ sky130_fd_sc_hd__nand4_1
X_06160_ _00528_ _00529_ _00482_ VSS VSS VDD VDD _00530_ sky130_fd_sc_hd__nand3_1
X_06161_ net155 net122 _00491_ VSS VSS VDD VDD _00531_ sky130_fd_sc_hd__o21ai_0
X_06162_ _00530_ _00488_ _00531_ VSS VSS VDD VDD _00001_ sky130_fd_sc_hd__a21oi_1
X_06163_ _00334_ VSS VSS VDD VDD _00532_ sky130_fd_sc_hd__inv_2
X_06164_ _00510_ _00532_ VSS VSS VDD VDD _00533_ sky130_fd_sc_hd__nand2_1
X_06165_ _00533_ _00471_ VSS VSS VDD VDD _00534_ sky130_fd_sc_hd__nor2_1
X_06166_ _00294_ _00534_ VSS VSS VDD VDD _00535_ sky130_fd_sc_hd__nor2_2
X_06167_ _00444_ _00468_ _00338_ VSS VSS VDD VDD _00536_ sky130_fd_sc_hd__nand3_1
X_06168_ _00535_ _00536_ VSS VSS VDD VDD _00537_ sky130_fd_sc_hd__nand2_1
X_06169_ _00298_ _00302_ _00318_ VSS VSS VDD VDD _00538_ sky130_fd_sc_hd__nor3_1
X_06170_ _00537_ _00538_ VSS VSS VDD VDD _00539_ sky130_fd_sc_hd__nand2_1
X_06171_ net116 net117 net118 net119 _00331_ VSS VSS VDD VDD
+ _00540_ sky130_fd_sc_hd__o41ai_1
X_06172_ _00539_ _00540_ VSS VSS VDD VDD _00541_ sky130_fd_sc_hd__nand2_1
X_06173_ _00541_ _00328_ VSS VSS VDD VDD _00542_ sky130_fd_sc_hd__nand2_1
X_06174_ _00539_ _00327_ _00540_ VSS VSS VDD VDD _00543_ sky130_fd_sc_hd__nand3_1
X_06175_ _00542_ _00482_ _00543_ VSS VSS VDD VDD _00544_ sky130_fd_sc_hd__nand3_1
X_06176_ net155 net121 _00491_ VSS VSS VDD VDD _00545_ sky130_fd_sc_hd__o21ai_0
X_06177_ _00544_ _00488_ _00545_ VSS VSS VDD VDD _00002_ sky130_fd_sc_hd__a21oi_1
X_06178_ _00506_ VSS VSS VDD VDD _00546_ sky130_fd_sc_hd__inv_1
X_06179_ _00546_ _00521_ VSS VSS VDD VDD _00547_ sky130_fd_sc_hd__nor2_1
X_06180_ _00547_ _00504_ VSS VSS VDD VDD _00548_ sky130_fd_sc_hd__nand2_1
X_06181_ _00521_ VSS VSS VDD VDD _00549_ sky130_fd_sc_hd__inv_1
X_06182_ _00511_ _00549_ VSS VSS VDD VDD _00550_ sky130_fd_sc_hd__nand2_1
X_06183_ _00548_ _00550_ _00508_ _00514_ VSS VSS VDD VDD _00551_
+ sky130_fd_sc_hd__nand4_1
X_06184_ net115 net116 net117 net118 _00331_ VSS VSS VDD VDD
+ _00552_ sky130_fd_sc_hd__o41ai_1
X_06185_ _00551_ _00552_ VSS VSS VDD VDD _00553_ sky130_fd_sc_hd__nand2_1
X_06186_ _00553_ _00317_ VSS VSS VDD VDD _00554_ sky130_fd_sc_hd__nand2_1
X_06187_ _00551_ _00316_ _00552_ VSS VSS VDD VDD _00555_ sky130_fd_sc_hd__nand3_1
X_06188_ _00554_ _00482_ _00555_ VSS VSS VDD VDD _00556_ sky130_fd_sc_hd__nand3_1
X_06189_ net155 net119 _00491_ VSS VSS VDD VDD _00557_ sky130_fd_sc_hd__o21ai_0
X_06190_ _00556_ _00488_ _00557_ VSS VSS VDD VDD _00003_ sky130_fd_sc_hd__a21oi_1
X_06191_ _00472_ _00303_ _00338_ VSS VSS VDD VDD _00558_ sky130_fd_sc_hd__nand3_1
X_06192_ _00307_ VSS VSS VDD VDD _00559_ sky130_fd_sc_hd__inv_1
X_06193_ _00558_ _00559_ VSS VSS VDD VDD _00560_ sky130_fd_sc_hd__nand2_1
X_06194_ _00560_ _00312_ VSS VSS VDD VDD _00561_ sky130_fd_sc_hd__nand2_1
X_06195_ _00558_ _00311_ _00559_ VSS VSS VDD VDD _00562_ sky130_fd_sc_hd__nand3_1
X_06196_ _00561_ _00482_ _00562_ VSS VSS VDD VDD _00563_ sky130_fd_sc_hd__nand3_1
Xoutput100 net100 VSS VSS VDD VDD c10[23] sky130_fd_sc_hd__clkdlybuf4s50_1
X_06198_ net155 net118 _00491_ VSS VSS VDD VDD _00565_ sky130_fd_sc_hd__o21ai_0
X_06199_ _00563_ _00488_ _00565_ VSS VSS VDD VDD _00004_ sky130_fd_sc_hd__a21oi_1
X_06200_ _00507_ _00512_ VSS VSS VDD VDD _00566_ sky130_fd_sc_hd__nand2_1
X_06201_ _00524_ VSS VSS VDD VDD _00567_ sky130_fd_sc_hd__inv_1
X_06202_ _00566_ _00567_ _00298_ VSS VSS VDD VDD _00568_ sky130_fd_sc_hd__a21oi_1
X_06203_ _00566_ _00298_ _00567_ VSS VSS VDD VDD _00569_ sky130_fd_sc_hd__nand3_1
X_06204_ _00568_ _00482_ _00569_ VSS VSS VDD VDD _00570_ sky130_fd_sc_hd__nand3b_1
Xoutput99 net99 VSS VSS VDD VDD c10[22] sky130_fd_sc_hd__clkdlybuf4s50_1
X_06206_ net155 net117 _00491_ VSS VSS VDD VDD _00572_ sky130_fd_sc_hd__o21ai_0
X_06207_ _00570_ _00488_ _00572_ VSS VSS VDD VDD _00005_ sky130_fd_sc_hd__a21oi_1
X_06208_ _00537_ _00301_ _00300_ VSS VSS VDD VDD _00573_ sky130_fd_sc_hd__nand3_1
X_06209_ _00535_ _00536_ _00302_ VSS VSS VDD VDD _00574_ sky130_fd_sc_hd__nand3_1
X_06210_ _00573_ _00574_ _00482_ VSS VSS VDD VDD _00575_ sky130_fd_sc_hd__nand3_1
X_06211_ net155 net116 _00491_ VSS VSS VDD VDD _00576_ sky130_fd_sc_hd__o21ai_0
X_06212_ _00575_ _00488_ _00576_ VSS VSS VDD VDD _00006_ sky130_fd_sc_hd__a21oi_1
X_06213_ _00548_ _00550_ VSS VSS VDD VDD _00577_ sky130_fd_sc_hd__and2_1
X_06214_ _00532_ _00577_ VSS VSS VDD VDD _00578_ sky130_fd_sc_hd__or2_0
X_06215_ _00577_ _00532_ VSS VSS VDD VDD _00579_ sky130_fd_sc_hd__nand2_1
X_06216_ _00578_ _00579_ _00482_ VSS VSS VDD VDD _00580_ sky130_fd_sc_hd__nand3_1
X_06217_ net155 net115 _00491_ VSS VSS VDD VDD _00581_ sky130_fd_sc_hd__o21ai_0
X_06218_ _00580_ _00488_ _00581_ VSS VSS VDD VDD _00007_ sky130_fd_sc_hd__a21oi_1
X_06219_ _00472_ _00337_ wrapped_design.pe10.start_out VSS
+ VSS VDD VDD _00582_ sky130_fd_sc_hd__a21oi_1
X_06220_ _00337_ _00472_ _00582_ VSS VSS VDD VDD _00583_ sky130_fd_sc_hd__o21ai_0
X_06221_ _00251_ _00253_ wrapped_design.pe10.start_out _00486_
+ VSS VSS VDD VDD _00584_ sky130_fd_sc_hd__a31oi_1
X_06222_ _00583_ _00584_ VSS VSS VDD VDD _00585_ sky130_fd_sc_hd__nand2_1
Xoutput98 net98 VSS VSS VDD VDD c10[21] sky130_fd_sc_hd__clkdlybuf4s50_1
X_06224_ _00486_ net114 VSS VSS VDD VDD _00587_ sky130_fd_sc_hd__nand2_1
Xoutput97 net97 VSS VSS VDD VDD c10[20] sky130_fd_sc_hd__clkdlybuf4s50_1
X_06226_ _00585_ _00587_ net164 VSS VSS VDD VDD _00008_ sky130_fd_sc_hd__a21oi_1
X_06227_ _00467_ _00507_ VSS VSS VDD VDD _00589_ sky130_fd_sc_hd__xor2_1
X_06228_ _00589_ _00482_ VSS VSS VDD VDD _00590_ sky130_fd_sc_hd__nand2_1
X_06229_ _00463_ wrapped_design.pe10.start_out VSS VSS VDD
+ VDD _00591_ sky130_fd_sc_hd__nand2_1
X_06230_ _00590_ net155 _00591_ VSS VSS VDD VDD _00592_ sky130_fd_sc_hd__nand3_1
X_06231_ _00486_ net113 VSS VSS VDD VDD _00593_ sky130_fd_sc_hd__nand2_1
X_06232_ _00592_ _00593_ net164 VSS VSS VDD VDD _00009_ sky130_fd_sc_hd__a21oi_1
Xoutput96 net96 VSS VSS VDD VDD c10[1] sky130_fd_sc_hd__clkdlybuf4s50_1
X_06234_ _00444_ _00453_ _00455_ VSS VSS VDD VDD _00595_ sky130_fd_sc_hd__nand3_1
X_06235_ _00434_ _00440_ _00443_ _00456_ VSS VSS VDD VDD _00596_
+ sky130_fd_sc_hd__nand4_1
X_06236_ wrapped_design.pe10.start_out _00486_ VSS VSS VDD
+ VDD _00597_ sky130_fd_sc_hd__nor2_1
X_06237_ net155 wrapped_design.pe10.start_out VSS VSS VDD
+ VDD _00598_ sky130_fd_sc_hd__nand2_1
X_06238_ _00598_ VSS VSS VDD VDD _00599_ sky130_fd_sc_hd__inv_1
X_06239_ _00452_ _00599_ VSS VSS VDD VDD _00600_ sky130_fd_sc_hd__nand2_1
X_06240_ net155 _00454_ _00600_ VSS VSS VDD VDD _00601_ sky130_fd_sc_hd__o21ai_0
X_06241_ _00595_ _00596_ _00597_ _00601_ VSS VSS VDD VDD _00602_
+ sky130_fd_sc_hd__a31oi_1
X_06242_ net164 _00602_ VSS VSS VDD VDD _00010_ sky130_fd_sc_hd__nor2_1
X_06243_ _00501_ _00503_ VSS VSS VDD VDD _00603_ sky130_fd_sc_hd__nand2_1
X_06244_ _00603_ _00494_ VSS VSS VDD VDD _00604_ sky130_fd_sc_hd__nand2_1
X_06245_ _00501_ _00503_ _00432_ VSS VSS VDD VDD _00605_ sky130_fd_sc_hd__nand3_1
X_06246_ _00604_ _00597_ _00605_ VSS VSS VDD VDD _00606_ sky130_fd_sc_hd__nand3_1
X_06247_ _00486_ net111 VSS VSS VDD VDD _00607_ sky130_fd_sc_hd__nand2_1
X_06248_ _00435_ _00599_ VSS VSS VDD VDD _00608_ sky130_fd_sc_hd__nand2_1
Xoutput95 net95 VSS VSS VDD VDD c10[19] sky130_fd_sc_hd__clkdlybuf4s50_1
X_06250_ _00606_ _00607_ _00608_ net164 VSS VSS VDD VDD _00011_
+ sky130_fd_sc_hd__a31oi_1
X_06251_ _00420_ _00346_ _00345_ VSS VSS VDD VDD _00610_ sky130_fd_sc_hd__nand3_1
X_06252_ _00610_ _00351_ _00346_ VSS VSS VDD VDD _00611_ sky130_fd_sc_hd__nand3_1
X_06253_ _00611_ _00421_ _00433_ VSS VSS VDD VDD _00612_ sky130_fd_sc_hd__a21oi_1
X_06254_ _00611_ _00433_ _00421_ VSS VSS VDD VDD _00613_ sky130_fd_sc_hd__nand3_1
X_06255_ _00612_ _00613_ _00597_ VSS VSS VDD VDD _00614_ sky130_fd_sc_hd__nand3b_1
X_06256_ _00486_ net110 VSS VSS VDD VDD _00615_ sky130_fd_sc_hd__nand2_1
X_06257_ _00437_ _00599_ VSS VSS VDD VDD _00616_ sky130_fd_sc_hd__nand2_1
X_06258_ _00614_ _00615_ _00616_ net164 VSS VSS VDD VDD _00012_
+ sky130_fd_sc_hd__a31oi_1
X_06259_ _00499_ _00497_ VSS VSS VDD VDD _00617_ sky130_fd_sc_hd__or2_2
X_06260_ _00617_ _00597_ _00500_ VSS VSS VDD VDD _00618_ sky130_fd_sc_hd__nand3_1
X_06261_ _00486_ net132 VSS VSS VDD VDD _00619_ sky130_fd_sc_hd__nand2_1
X_06262_ _00350_ _00599_ VSS VSS VDD VDD _00620_ sky130_fd_sc_hd__nand2_1
Xoutput94 net94 VSS VSS VDD VDD c10[18] sky130_fd_sc_hd__clkdlybuf4s50_1
X_06264_ _00618_ _00619_ _00620_ net164 VSS VSS VDD VDD _00013_
+ sky130_fd_sc_hd__a31oi_1
X_06265_ _00347_ _00419_ _00417_ VSS VSS VDD VDD _00622_ sky130_fd_sc_hd__nand3_1
X_06266_ net155 _00344_ _00598_ _00343_ VSS VSS VDD VDD _00623_
+ sky130_fd_sc_hd__o22ai_1
X_06267_ _00610_ _00622_ _00597_ _00623_ VSS VSS VDD VDD _00624_
+ sky130_fd_sc_hd__a31oi_1
X_06268_ net164 _00624_ VSS VSS VDD VDD _00014_ sky130_fd_sc_hd__nor2_1
X_06269_ _00410_ _00416_ VSS VSS VDD VDD _00625_ sky130_fd_sc_hd__nand2_1
X_06270_ _00419_ _00415_ VSS VSS VDD VDD _00626_ sky130_fd_sc_hd__nand2_1
X_06271_ _00625_ _00626_ VSS VSS VDD VDD _00627_ sky130_fd_sc_hd__xnor2_1
X_06272_ _00627_ _00482_ _00486_ VSS VSS VDD VDD _00628_ sky130_fd_sc_hd__a21oi_1
X_06273_ _00482_ _00418_ _00628_ VSS VSS VDD VDD _00629_ sky130_fd_sc_hd__o21ai_0
X_06274_ _00486_ net130 VSS VSS VDD VDD _00630_ sky130_fd_sc_hd__nand2_1
X_06275_ _00629_ _00630_ net164 VSS VSS VDD VDD _00015_ sky130_fd_sc_hd__a21oi_1
X_06276_ _00396_ _00409_ VSS VSS VDD VDD _00631_ sky130_fd_sc_hd__nand2_1
X_06277_ _00416_ _00407_ _00631_ VSS VSS VDD VDD _00632_ sky130_fd_sc_hd__a21oi_1
X_06278_ _00631_ _00416_ _00407_ VSS VSS VDD VDD _00633_ sky130_fd_sc_hd__nand3_1
X_06279_ _00632_ _00482_ _00633_ VSS VSS VDD VDD _00634_ sky130_fd_sc_hd__nand3b_1
X_06280_ _00402_ _00406_ wrapped_design.pe10.start_out VSS
+ VSS VDD VDD _00635_ sky130_fd_sc_hd__nand3_1
Xoutput93 net93 VSS VSS VDD VDD c10[17] sky130_fd_sc_hd__clkdlybuf4s50_1
X_06282_ net155 net129 _00491_ VSS VSS VDD VDD _00637_ sky130_fd_sc_hd__o21ai_0
X_06283_ _00634_ net155 _00635_ _00637_ VSS VSS VDD VDD _00016_
+ sky130_fd_sc_hd__a31oi_1
X_06284_ _00409_ _00395_ _00388_ VSS VSS VDD VDD _00638_ sky130_fd_sc_hd__a21oi_1
X_06285_ _00409_ _00388_ _00395_ VSS VSS VDD VDD _00639_ sky130_fd_sc_hd__nand3_1
X_06286_ _00638_ _00482_ _00639_ VSS VSS VDD VDD _00640_ sky130_fd_sc_hd__nand3b_1
X_06287_ _00408_ wrapped_design.pe10.start_out _00486_ VSS
+ VSS VDD VDD _00641_ sky130_fd_sc_hd__a21oi_1
X_06288_ _00486_ _00394_ _00640_ _00641_ net164 VSS VSS VDD
+ VDD _00017_ sky130_fd_sc_hd__a221oi_1
X_06289_ _00386_ VSS VSS VDD VDD _00642_ sky130_fd_sc_hd__inv_1
X_06290_ _00356_ _00387_ _00385_ VSS VSS VDD VDD _00643_ sky130_fd_sc_hd__a21oi_1
X_06291_ _00642_ _00387_ wrapped_design.pe10.start_out _00643_
+ VSS VSS VDD VDD _00644_ sky130_fd_sc_hd__a211o_1
X_06292_ _00355_ wrapped_design.pe10.start_out VSS VSS VDD
+ VDD _00645_ sky130_fd_sc_hd__nand2_1
Xoutput92 net92 VSS VSS VDD VDD c10[16] sky130_fd_sc_hd__clkdlybuf4s50_1
X_06294_ net155 net127 _00491_ VSS VSS VDD VDD _00647_ sky130_fd_sc_hd__o21ai_0
X_06295_ _00644_ net155 _00645_ _00647_ VSS VSS VDD VDD _00018_
+ sky130_fd_sc_hd__a31oi_1
X_06296_ _00382_ _00375_ VSS VSS VDD VDD _00648_ sky130_fd_sc_hd__or2_2
X_06297_ _00648_ _00383_ _00597_ VSS VSS VDD VDD _00649_ sky130_fd_sc_hd__nand3_1
X_06298_ net155 _00376_ _00598_ _00379_ VSS VSS VDD VDD _00650_
+ sky130_fd_sc_hd__o22ai_1
X_06299_ _00650_ VSS VSS VDD VDD _00651_ sky130_fd_sc_hd__inv_1
X_06300_ _00649_ _00651_ net164 VSS VSS VDD VDD _00019_ sky130_fd_sc_hd__a21oi_1
X_06301_ _00370_ VSS VSS VDD VDD _00652_ sky130_fd_sc_hd__inv_1
X_06302_ _00373_ _00367_ _00652_ VSS VSS VDD VDD _00653_ sky130_fd_sc_hd__nand3b_1
X_06303_ _00653_ _00374_ _00597_ VSS VSS VDD VDD _00654_ sky130_fd_sc_hd__nand3_1
X_06304_ net155 _00357_ _00598_ _00359_ VSS VSS VDD VDD _00655_
+ sky130_fd_sc_hd__o22ai_1
X_06305_ _00655_ VSS VSS VDD VDD _00656_ sky130_fd_sc_hd__inv_1
X_06306_ _00654_ _00656_ net164 VSS VSS VDD VDD _00020_ sky130_fd_sc_hd__a21oi_1
X_06307_ _00369_ _00366_ VSS VSS VDD VDD _00657_ sky130_fd_sc_hd__nand2_1
X_06308_ _00652_ _00597_ _00657_ VSS VSS VDD VDD _00658_ sky130_fd_sc_hd__nand3_1
X_06309_ net155 _00360_ _00598_ _00362_ VSS VSS VDD VDD _00659_
+ sky130_fd_sc_hd__o22ai_1
X_06310_ _00659_ VSS VSS VDD VDD _00660_ sky130_fd_sc_hd__inv_1
X_06311_ _00658_ _00660_ net164 VSS VSS VDD VDD _00021_ sky130_fd_sc_hd__a21oi_1
X_06312_ _00486_ _03131_ _00364_ _00599_ VSS VSS VDD VDD _00661_
+ sky130_fd_sc_hd__o22ai_1
X_06313_ _00661_ _00491_ VSS VSS VDD VDD _00662_ sky130_fd_sc_hd__nand2_1
X_06314_ net155 net109 _03169_ _00598_ _00662_ VSS VSS VDD
+ VDD _00022_ sky130_fd_sc_hd__a41oi_1
Xoutput91 net91 VSS VSS VDD VDD c10[15] sky130_fd_sc_hd__clkdlybuf4s50_1
X_06316_ net163 VSS VSS VDD VDD _00664_ sky130_fd_sc_hd__inv_2
Xoutput90 net90 VSS VSS VDD VDD c10[14] sky130_fd_sc_hd__clkdlybuf4s50_1
Xoutput89 net89 VSS VSS VDD VDD c10[13] sky130_fd_sc_hd__clkdlybuf4s50_1
Xoutput88 net88 VSS VSS VDD VDD c10[12] sky130_fd_sc_hd__clkdlybuf4s50_1
X_06320_ wrapped_design.a1_skew\[6\] VSS VSS VDD VDD _00668_
+ sky130_fd_sc_hd__inv_1
Xoutput87 net87 VSS VSS VDD VDD c10[11] sky130_fd_sc_hd__clkdlybuf4s50_1
X_06322_ net6 net159 net161 VSS VSS VDD VDD _00670_ sky130_fd_sc_hd__o21ai_0
X_06323_ net159 _00668_ _00670_ VSS VSS VDD VDD _00023_ sky130_fd_sc_hd__a21oi_1
Xoutput86 net86 VSS VSS VDD VDD c10[10] sky130_fd_sc_hd__clkdlybuf4s50_1
X_06325_ wrapped_design.a1_skew\[5\] VSS VSS VDD VDD _00672_
+ sky130_fd_sc_hd__inv_2
X_06326_ net5 net159 net161 VSS VSS VDD VDD _00673_ sky130_fd_sc_hd__o21ai_0
X_06327_ net159 _00672_ _00673_ VSS VSS VDD VDD _00024_ sky130_fd_sc_hd__a21oi_1
Xoutput85 net85 VSS VSS VDD VDD c10[0] sky130_fd_sc_hd__clkdlybuf4s50_1
X_06329_ wrapped_design.a1_skew\[4\] VSS VSS VDD VDD _00675_
+ sky130_fd_sc_hd__inv_2
X_06330_ net4 net159 net161 VSS VSS VDD VDD _00676_ sky130_fd_sc_hd__o21ai_0
X_06331_ net159 _00675_ _00676_ VSS VSS VDD VDD _00025_ sky130_fd_sc_hd__a21oi_1
Xoutput84 net84 VSS VSS VDD VDD c01[9] sky130_fd_sc_hd__clkdlybuf4s50_1
X_06333_ wrapped_design.a1_skew\[3\] VSS VSS VDD VDD _00678_
+ sky130_fd_sc_hd__inv_2
X_06334_ net3 net159 net161 VSS VSS VDD VDD _00679_ sky130_fd_sc_hd__o21ai_0
X_06335_ net159 _00678_ _00679_ VSS VSS VDD VDD _00026_ sky130_fd_sc_hd__a21oi_1
Xoutput83 net83 VSS VSS VDD VDD c01[8] sky130_fd_sc_hd__clkdlybuf4s50_1
X_06337_ wrapped_design.a1_skew\[2\] VSS VSS VDD VDD _00681_
+ sky130_fd_sc_hd__inv_2
X_06338_ net2 net159 net161 VSS VSS VDD VDD _00682_ sky130_fd_sc_hd__o21ai_0
X_06339_ net159 _00681_ _00682_ VSS VSS VDD VDD _00027_ sky130_fd_sc_hd__a21oi_1
Xoutput82 net82 VSS VSS VDD VDD c01[7] sky130_fd_sc_hd__clkdlybuf4s50_1
X_06341_ wrapped_design.a1_skew\[1\] VSS VSS VDD VDD _00684_
+ sky130_fd_sc_hd__inv_2
X_06342_ net16 net159 net161 VSS VSS VDD VDD _00685_ sky130_fd_sc_hd__o21ai_0
X_06343_ net159 _00684_ _00685_ VSS VSS VDD VDD _00028_ sky130_fd_sc_hd__a21oi_1
Xoutput81 net81 VSS VSS VDD VDD c01[6] sky130_fd_sc_hd__clkdlybuf4s50_1
X_06345_ wrapped_design.a1_skew\[0\] VSS VSS VDD VDD _00687_
+ sky130_fd_sc_hd__inv_2
Xoutput80 net80 VSS VSS VDD VDD c01[5] sky130_fd_sc_hd__clkdlybuf4s50_1
X_06347_ net15 net159 net161 VSS VSS VDD VDD _00689_ sky130_fd_sc_hd__o21ai_0
X_06348_ net159 _00687_ _00689_ VSS VSS VDD VDD _00029_ sky130_fd_sc_hd__a21oi_1
Xoutput79 net79 VSS VSS VDD VDD c01[4] sky130_fd_sc_hd__clkdlybuf4s50_1
X_06350_ net22 net159 VSS VSS VDD VDD _00691_ sky130_fd_sc_hd__nor2_1
Xoutput78 net78 VSS VSS VDD VDD c01[3] sky130_fd_sc_hd__clkdlybuf4s50_1
Xoutput77 net77 VSS VSS VDD VDD c01[2] sky130_fd_sc_hd__clkdlybuf4s50_1
Xoutput76 net76 VSS VSS VDD VDD c01[23] sky130_fd_sc_hd__clkdlybuf4s50_1
X_06354_ net163 wrapped_design.b1_skew\[6\] net161 VSS VSS
+ VDD VDD _00695_ sky130_fd_sc_hd__o21ai_0
X_06355_ _00691_ _00695_ VSS VSS VDD VDD _00030_ sky130_fd_sc_hd__nor2_1
X_06356_ net21 net159 VSS VSS VDD VDD _00696_ sky130_fd_sc_hd__nor2_1
Xoutput75 net75 VSS VSS VDD VDD c01[22] sky130_fd_sc_hd__clkdlybuf4s50_1
X_06358_ net163 wrapped_design.b1_skew\[5\] net161 VSS VSS
+ VDD VDD _00698_ sky130_fd_sc_hd__o21ai_0
X_06359_ _00696_ _00698_ VSS VSS VDD VDD _00031_ sky130_fd_sc_hd__nor2_1
Xoutput74 net74 VSS VSS VDD VDD c01[21] sky130_fd_sc_hd__clkdlybuf4s50_1
X_06361_ wrapped_design.b1_skew\[4\] VSS VSS VDD VDD _00700_
+ sky130_fd_sc_hd__inv_1
X_06362_ net20 net159 net160 VSS VSS VDD VDD _00701_ sky130_fd_sc_hd__o21ai_0
X_06363_ net159 _00700_ _00701_ VSS VSS VDD VDD _00032_ sky130_fd_sc_hd__a21oi_1
X_06364_ net19 net159 VSS VSS VDD VDD _00702_ sky130_fd_sc_hd__nor2_1
Xoutput73 net73 VSS VSS VDD VDD c01[20] sky130_fd_sc_hd__clkdlybuf4s50_1
X_06366_ net163 wrapped_design.b1_skew\[3\] net161 VSS VSS
+ VDD VDD _00704_ sky130_fd_sc_hd__o21ai_0
X_06367_ _00702_ _00704_ VSS VSS VDD VDD _00033_ sky130_fd_sc_hd__nor2_1
X_06368_ net18 net159 VSS VSS VDD VDD _00705_ sky130_fd_sc_hd__nor2_1
Xoutput72 net72 VSS VSS VDD VDD c01[1] sky130_fd_sc_hd__clkdlybuf4s50_1
Xoutput71 net71 VSS VSS VDD VDD c01[19] sky130_fd_sc_hd__clkdlybuf4s50_1
X_06371_ net163 wrapped_design.b1_skew\[2\] net160 VSS VSS
+ VDD VDD _00708_ sky130_fd_sc_hd__o21ai_0
X_06372_ _00705_ _00708_ VSS VSS VDD VDD _00034_ sky130_fd_sc_hd__nor2_1
X_06373_ net32 net159 VSS VSS VDD VDD _00709_ sky130_fd_sc_hd__nor2_1
Xoutput70 net70 VSS VSS VDD VDD c01[18] sky130_fd_sc_hd__clkdlybuf4s50_1
X_06375_ net163 wrapped_design.b1_skew\[1\] net160 VSS VSS
+ VDD VDD _00711_ sky130_fd_sc_hd__o21ai_0
X_06376_ _00709_ _00711_ VSS VSS VDD VDD _00035_ sky130_fd_sc_hd__nor2_1
Xoutput69 net69 VSS VSS VDD VDD c01[17] sky130_fd_sc_hd__clkdlybuf4s50_1
X_06378_ wrapped_design.b1_skew\[0\] VSS VSS VDD VDD _00713_
+ sky130_fd_sc_hd__inv_1
X_06379_ net31 net159 net160 VSS VSS VDD VDD _00714_ sky130_fd_sc_hd__o21ai_0
X_06380_ net159 _00713_ _00714_ VSS VSS VDD VDD _00036_ sky130_fd_sc_hd__a21oi_1
Xoutput68 net68 VSS VSS VDD VDD c01[16] sky130_fd_sc_hd__clkdlybuf4s50_1
Xoutput67 net67 VSS VSS VDD VDD c01[15] sky130_fd_sc_hd__clkdlybuf4s50_1
Xoutput66 net66 VSS VSS VDD VDD c01[14] sky130_fd_sc_hd__clkdlybuf4s50_1
Xoutput65 net65 VSS VSS VDD VDD c01[13] sky130_fd_sc_hd__clkdlybuf4s50_1
X_06385_ net156 wrapped_design.a10_right\[6\] net160 VSS VSS
+ VDD VDD _00719_ sky130_fd_sc_hd__o21ai_0
X_06386_ net156 _00668_ _00719_ VSS VSS VDD VDD _00037_ sky130_fd_sc_hd__a21oi_1
Xoutput64 net64 VSS VSS VDD VDD c01[12] sky130_fd_sc_hd__clkdlybuf4s50_1
X_06388_ net156 wrapped_design.a10_right\[5\] net160 VSS VSS
+ VDD VDD _00721_ sky130_fd_sc_hd__o21ai_0
X_06389_ net156 _00672_ _00721_ VSS VSS VDD VDD _00038_ sky130_fd_sc_hd__a21oi_1
X_06390_ net156 wrapped_design.a10_right\[4\] net160 VSS VSS
+ VDD VDD _00722_ sky130_fd_sc_hd__o21ai_0
X_06391_ net156 _00675_ _00722_ VSS VSS VDD VDD _00039_ sky130_fd_sc_hd__a21oi_1
X_06392_ net156 wrapped_design.a10_right\[3\] net161 VSS VSS
+ VDD VDD _00723_ sky130_fd_sc_hd__o21ai_0
X_06393_ net156 _00678_ _00723_ VSS VSS VDD VDD _00040_ sky130_fd_sc_hd__a21oi_1
X_06394_ net156 wrapped_design.a10_right\[2\] net160 VSS VSS
+ VDD VDD _00724_ sky130_fd_sc_hd__o21ai_0
X_06395_ net156 _00681_ _00724_ VSS VSS VDD VDD _00041_ sky130_fd_sc_hd__a21oi_1
X_06396_ net156 wrapped_design.a10_right\[1\] net160 VSS VSS
+ VDD VDD _00725_ sky130_fd_sc_hd__o21ai_0
X_06397_ net156 _00684_ _00725_ VSS VSS VDD VDD _00042_ sky130_fd_sc_hd__a21oi_1
X_06398_ net156 wrapped_design.a10_right\[0\] net160 VSS VSS
+ VDD VDD _00726_ sky130_fd_sc_hd__o21ai_0
X_06399_ net156 _00687_ _00726_ VSS VSS VDD VDD _00043_ sky130_fd_sc_hd__a21oi_1
Xoutput63 net63 VSS VSS VDD VDD c01[11] sky130_fd_sc_hd__clkdlybuf4s50_1
Xoutput62 net62 VSS VSS VDD VDD c01[10] sky130_fd_sc_hd__clkdlybuf4s50_1
X_06402_ net30 VSS VSS VDD VDD _00729_ sky130_fd_sc_hd__inv_6
X_06403_ net1 _00729_ VSS VSS VDD VDD _00730_ sky130_fd_sc_hd__nor2_2
Xoutput61 net61 VSS VSS VDD VDD c01[0] sky130_fd_sc_hd__clkdlybuf4s50_1
X_06405_ net8 net29 VSS VSS VDD VDD _00732_ sky130_fd_sc_hd__nand2_2
X_06406_ _00732_ VSS VSS VDD VDD _00733_ sky130_fd_sc_hd__inv_1
X_06407_ _00730_ _00733_ VSS VSS VDD VDD _00734_ sky130_fd_sc_hd__nand2_2
X_06408_ net1 VSS VSS VDD VDD _00735_ sky130_fd_sc_hd__inv_1
X_06409_ _00735_ net30 VSS VSS VDD VDD _00736_ sky130_fd_sc_hd__nand2_1
X_06410_ _00736_ _00732_ VSS VSS VDD VDD _00737_ sky130_fd_sc_hd__nand2_1
X_06411_ _00734_ _00737_ VSS VSS VDD VDD _00738_ sky130_fd_sc_hd__nand2_1
Xoutput60 net60 VSS VSS VDD VDD c00[9] sky130_fd_sc_hd__clkdlybuf4s50_1
Xoutput59 net59 VSS VSS VDD VDD c00[8] sky130_fd_sc_hd__clkdlybuf4s50_1
X_06414_ net9 net28 VSS VSS VDD VDD _00741_ sky130_fd_sc_hd__nand2_1
X_06415_ _00741_ VSS VSS VDD VDD _00742_ sky130_fd_sc_hd__inv_1
X_06416_ _00738_ _00742_ VSS VSS VDD VDD _00743_ sky130_fd_sc_hd__nand2_1
X_06417_ _00734_ _00737_ _00741_ VSS VSS VDD VDD _00744_ sky130_fd_sc_hd__nand3_1
X_06418_ _00743_ _00744_ VSS VSS VDD VDD _00745_ sky130_fd_sc_hd__nand2_1
X_06419_ net1 net28 VSS VSS VDD VDD _00746_ sky130_fd_sc_hd__nand2_1
X_06420_ _00732_ _00746_ VSS VSS VDD VDD _00747_ sky130_fd_sc_hd__nor2_1
X_06421_ _00745_ _00747_ VSS VSS VDD VDD _00748_ sky130_fd_sc_hd__nand2_1
X_06422_ _00738_ _00741_ VSS VSS VDD VDD _00749_ sky130_fd_sc_hd__nand2_1
X_06423_ _00734_ _00737_ _00742_ VSS VSS VDD VDD _00750_ sky130_fd_sc_hd__nand3_1
X_06424_ _00749_ _00750_ VSS VSS VDD VDD _00751_ sky130_fd_sc_hd__nand2_1
X_06425_ _00747_ VSS VSS VDD VDD _00752_ sky130_fd_sc_hd__inv_1
X_06426_ _00751_ _00752_ VSS VSS VDD VDD _00753_ sky130_fd_sc_hd__nand2_1
X_06427_ _00748_ _00753_ VSS VSS VDD VDD _00754_ sky130_fd_sc_hd__nand2_1
Xoutput58 net58 VSS VSS VDD VDD c00[7] sky130_fd_sc_hd__clkdlybuf4s50_1
Xoutput57 net57 VSS VSS VDD VDD c00[6] sky130_fd_sc_hd__clkdlybuf4s50_1
X_06430_ net12 net25 VSS VSS VDD VDD _00757_ sky130_fd_sc_hd__nand2_1
Xoutput56 net56 VSS VSS VDD VDD c00[5] sky130_fd_sc_hd__clkdlybuf4s50_1
Xoutput55 net55 VSS VSS VDD VDD c00[4] sky130_fd_sc_hd__clkdlybuf4s50_1
X_06433_ net11 net26 VSS VSS VDD VDD _00760_ sky130_fd_sc_hd__nand2_1
X_06434_ _00760_ VSS VSS VDD VDD _00761_ sky130_fd_sc_hd__inv_1
Xoutput54 net54 VSS VSS VDD VDD c00[3] sky130_fd_sc_hd__clkdlybuf4s50_1
X_06436_ net10 net27 VSS VSS VDD VDD _00763_ sky130_fd_sc_hd__nand2_1
X_06437_ _00763_ VSS VSS VDD VDD _00764_ sky130_fd_sc_hd__inv_1
X_06438_ _00761_ _00764_ VSS VSS VDD VDD _00765_ sky130_fd_sc_hd__nand2_1
X_06439_ _00760_ _00763_ VSS VSS VDD VDD _00766_ sky130_fd_sc_hd__nand2_1
X_06440_ _00765_ _00766_ VSS VSS VDD VDD _00767_ sky130_fd_sc_hd__nand2_1
X_06441_ _00757_ _00767_ VSS VSS VDD VDD _00768_ sky130_fd_sc_hd__nor2_1
X_06442_ _00768_ VSS VSS VDD VDD _00769_ sky130_fd_sc_hd__inv_1
X_06443_ _00767_ _00757_ VSS VSS VDD VDD _00770_ sky130_fd_sc_hd__nand2_1
X_06444_ _00769_ _00770_ VSS VSS VDD VDD _00771_ sky130_fd_sc_hd__nand2_1
X_06445_ _00754_ _00771_ VSS VSS VDD VDD _00772_ sky130_fd_sc_hd__nand2_1
X_06446_ _00770_ VSS VSS VDD VDD _00773_ sky130_fd_sc_hd__inv_1
X_06447_ _00768_ _00773_ VSS VSS VDD VDD _00774_ sky130_fd_sc_hd__nor2_1
X_06448_ _00748_ _00753_ _00774_ VSS VSS VDD VDD _00775_ sky130_fd_sc_hd__nand3_2
X_06449_ _00772_ _00775_ VSS VSS VDD VDD _00776_ sky130_fd_sc_hd__nand2_1
X_06450_ net9 net26 VSS VSS VDD VDD _00777_ sky130_fd_sc_hd__nand2_1
X_06451_ _00777_ VSS VSS VDD VDD _00778_ sky130_fd_sc_hd__inv_1
X_06452_ _00764_ _00778_ VSS VSS VDD VDD _00779_ sky130_fd_sc_hd__nand2_1
X_06453_ net10 net26 VSS VSS VDD VDD _00780_ sky130_fd_sc_hd__nand2_1
Xoutput53 net53 VSS VSS VDD VDD c00[2] sky130_fd_sc_hd__clkdlybuf4s50_1
X_06455_ net9 net27 VSS VSS VDD VDD _00782_ sky130_fd_sc_hd__nand2_1
X_06456_ _00780_ _00782_ VSS VSS VDD VDD _00783_ sky130_fd_sc_hd__nand2_1
X_06457_ _00779_ _00783_ VSS VSS VDD VDD _00784_ sky130_fd_sc_hd__nand2_1
X_06458_ net11 net25 VSS VSS VDD VDD _00785_ sky130_fd_sc_hd__nand2_1
X_06459_ _00784_ _00785_ VSS VSS VDD VDD _00786_ sky130_fd_sc_hd__nand2_1
X_06460_ _00785_ VSS VSS VDD VDD _00787_ sky130_fd_sc_hd__inv_1
X_06461_ _00779_ _00787_ _00783_ VSS VSS VDD VDD _00788_ sky130_fd_sc_hd__nand3_1
X_06462_ net8 net28 VSS VSS VDD VDD _00789_ sky130_fd_sc_hd__nand2_1
Xoutput52 net52 VSS VSS VDD VDD c00[23] sky130_fd_sc_hd__clkdlybuf4s50_1
X_06464_ net1 net29 VSS VSS VDD VDD _00791_ sky130_fd_sc_hd__nand2_1
X_06465_ _00789_ _00791_ VSS VSS VDD VDD _00792_ sky130_fd_sc_hd__nand2_1
X_06466_ _00792_ VSS VSS VDD VDD _00793_ sky130_fd_sc_hd__inv_1
X_06467_ _00747_ _00793_ VSS VSS VDD VDD _00794_ sky130_fd_sc_hd__nor2_2
X_06468_ _00786_ _00788_ _00794_ VSS VSS VDD VDD _00795_ sky130_fd_sc_hd__nand3_1
X_06469_ _00776_ _00795_ VSS VSS VDD VDD _00796_ sky130_fd_sc_hd__nand2_1
X_06470_ _00795_ VSS VSS VDD VDD _00797_ sky130_fd_sc_hd__inv_1
X_06471_ _00772_ _00775_ _00797_ VSS VSS VDD VDD _00798_ sky130_fd_sc_hd__nand3_1
Xoutput51 net51 VSS VSS VDD VDD c00[22] sky130_fd_sc_hd__clkdlybuf4s50_1
Xoutput50 net50 VSS VSS VDD VDD c00[21] sky130_fd_sc_hd__clkdlybuf4s50_1
X_06474_ net14 net24 VSS VSS VDD VDD _00801_ sky130_fd_sc_hd__nand2_1
Xoutput49 net49 VSS VSS VDD VDD c00[20] sky130_fd_sc_hd__clkdlybuf4s50_1
Xoutput48 net48 VSS VSS VDD VDD c00[1] sky130_fd_sc_hd__clkdlybuf4s50_1
X_06477_ net13 net17 VSS VSS VDD VDD _00804_ sky130_fd_sc_hd__nand2_1
X_06478_ net14 net17 VSS VSS VDD VDD _00805_ sky130_fd_sc_hd__nand2_1
X_06479_ net13 net24 VSS VSS VDD VDD _00806_ sky130_fd_sc_hd__nand2_1
X_06480_ _00805_ _00806_ VSS VSS VDD VDD _00807_ sky130_fd_sc_hd__nand2_1
X_06481_ _00801_ _00804_ _00807_ VSS VSS VDD VDD _00808_ sky130_fd_sc_hd__o21ai_1
X_06482_ _00808_ VSS VSS VDD VDD _00809_ sky130_fd_sc_hd__inv_1
X_06483_ _00809_ net30 VSS VSS VDD VDD _00810_ sky130_fd_sc_hd__nand2_1
X_06484_ _00808_ _00729_ VSS VSS VDD VDD _00811_ sky130_fd_sc_hd__nand2_1
X_06485_ _00810_ _00811_ VSS VSS VDD VDD _00812_ sky130_fd_sc_hd__nand2_1
X_06486_ _00788_ _00779_ VSS VSS VDD VDD _00813_ sky130_fd_sc_hd__nand2_1
X_06487_ _00813_ VSS VSS VDD VDD _00814_ sky130_fd_sc_hd__inv_1
X_06488_ _00812_ _00814_ VSS VSS VDD VDD _00815_ sky130_fd_sc_hd__nand2_1
X_06489_ _00813_ _00810_ _00811_ VSS VSS VDD VDD _00816_ sky130_fd_sc_hd__nand3_1
X_06490_ _00815_ _00816_ VSS VSS VDD VDD _00817_ sky130_fd_sc_hd__nand2_1
X_06491_ net12 net17 VSS VSS VDD VDD _00818_ sky130_fd_sc_hd__nand2_1
X_06492_ _00806_ _00818_ VSS VSS VDD VDD _00819_ sky130_fd_sc_hd__nor2_1
X_06493_ _00817_ _00819_ VSS VSS VDD VDD _00820_ sky130_fd_sc_hd__nand2_1
X_06494_ _00819_ VSS VSS VDD VDD _00821_ sky130_fd_sc_hd__inv_1
X_06495_ _00815_ _00816_ _00821_ VSS VSS VDD VDD _00822_ sky130_fd_sc_hd__nand3_1
X_06496_ _00820_ _00822_ VSS VSS VDD VDD _00823_ sky130_fd_sc_hd__nand2_1
X_06497_ _00796_ _00798_ _00823_ VSS VSS VDD VDD _00824_ sky130_fd_sc_hd__nand3_2
X_06498_ _00776_ _00797_ VSS VSS VDD VDD _00825_ sky130_fd_sc_hd__nand2_1
X_06499_ _00772_ _00775_ _00795_ VSS VSS VDD VDD _00826_ sky130_fd_sc_hd__nand3_1
X_06500_ _00817_ _00821_ VSS VSS VDD VDD _00827_ sky130_fd_sc_hd__nand2_1
X_06501_ _00815_ _00816_ _00819_ VSS VSS VDD VDD _00828_ sky130_fd_sc_hd__nand3_1
X_06502_ _00827_ _00828_ VSS VSS VDD VDD _00829_ sky130_fd_sc_hd__nand2_1
X_06503_ _00825_ _00826_ _00829_ VSS VSS VDD VDD _00830_ sky130_fd_sc_hd__nand3_1
X_06504_ _00784_ _00787_ VSS VSS VDD VDD _00831_ sky130_fd_sc_hd__nand2_1
X_06505_ _00794_ VSS VSS VDD VDD _00832_ sky130_fd_sc_hd__inv_2
X_06506_ _00779_ _00785_ _00783_ VSS VSS VDD VDD _00833_ sky130_fd_sc_hd__nand3_1
X_06507_ _00831_ _00832_ _00833_ VSS VSS VDD VDD _00834_ sky130_fd_sc_hd__nand3_1
X_06508_ _00834_ _00795_ VSS VSS VDD VDD _00835_ sky130_fd_sc_hd__nand2_1
X_06509_ net8 net27 VSS VSS VDD VDD _00836_ sky130_fd_sc_hd__nand2_1
X_06510_ _00836_ VSS VSS VDD VDD _00837_ sky130_fd_sc_hd__inv_1
X_06511_ _00778_ _00837_ VSS VSS VDD VDD _00838_ sky130_fd_sc_hd__nand2_1
X_06512_ _00777_ _00836_ VSS VSS VDD VDD _00839_ sky130_fd_sc_hd__nand2_1
X_06513_ _00838_ _00839_ VSS VSS VDD VDD _00840_ sky130_fd_sc_hd__nand2_1
X_06514_ net10 net25 VSS VSS VDD VDD _00841_ sky130_fd_sc_hd__nand2_1
X_06515_ _00840_ _00841_ VSS VSS VDD VDD _00842_ sky130_fd_sc_hd__nand2_1
X_06516_ _00746_ VSS VSS VDD VDD _00843_ sky130_fd_sc_hd__inv_1
X_06517_ _00841_ VSS VSS VDD VDD _00844_ sky130_fd_sc_hd__inv_1
X_06518_ _00838_ _00844_ _00839_ VSS VSS VDD VDD _00845_ sky130_fd_sc_hd__nand3_1
X_06519_ _00842_ _00843_ _00845_ VSS VSS VDD VDD _00846_ sky130_fd_sc_hd__nand3_1
X_06520_ _00846_ VSS VSS VDD VDD _00847_ sky130_fd_sc_hd__inv_1
X_06521_ _00835_ _00847_ VSS VSS VDD VDD _00848_ sky130_fd_sc_hd__nand2_1
X_06522_ _00786_ _00832_ _00788_ VSS VSS VDD VDD _00849_ sky130_fd_sc_hd__nand3_1
X_06523_ _00831_ _00833_ _00794_ VSS VSS VDD VDD _00850_ sky130_fd_sc_hd__nand3_1
X_06524_ _00849_ _00850_ VSS VSS VDD VDD _00851_ sky130_fd_sc_hd__nand2_1
X_06525_ _00851_ _00846_ VSS VSS VDD VDD _00852_ sky130_fd_sc_hd__nand2_1
X_06526_ _00848_ _00852_ VSS VSS VDD VDD _00853_ sky130_fd_sc_hd__nand2_1
X_06527_ net12 net24 VSS VSS VDD VDD _00854_ sky130_fd_sc_hd__nand2_1
X_06528_ _00804_ _00854_ VSS VSS VDD VDD _00855_ sky130_fd_sc_hd__nand2_1
X_06529_ _00821_ _00855_ VSS VSS VDD VDD _00856_ sky130_fd_sc_hd__nand2_1
X_06530_ net8 net26 VSS VSS VDD VDD _00857_ sky130_fd_sc_hd__nand2_1
X_06531_ _00782_ _00857_ VSS VSS VDD VDD _00858_ sky130_fd_sc_hd__nor2_1
X_06532_ _00839_ _00844_ _00858_ VSS VSS VDD VDD _00859_ sky130_fd_sc_hd__a21oi_1
X_06533_ _00856_ _00859_ VSS VSS VDD VDD _00860_ sky130_fd_sc_hd__nor2_1
X_06534_ _00859_ _00856_ VSS VSS VDD VDD _00861_ sky130_fd_sc_hd__nand2_1
X_06535_ _00861_ VSS VSS VDD VDD _00862_ sky130_fd_sc_hd__inv_1
X_06536_ net11 net17 VSS VSS VDD VDD _00863_ sky130_fd_sc_hd__nand2_1
X_06537_ _00854_ _00863_ VSS VSS VDD VDD _00864_ sky130_fd_sc_hd__nor2_2
X_06538_ _00860_ _00862_ _00864_ VSS VSS VDD VDD _00865_ sky130_fd_sc_hd__o21ai_0
X_06539_ _00860_ _00862_ VSS VSS VDD VDD _00866_ sky130_fd_sc_hd__nor2_1
X_06540_ _00864_ VSS VSS VDD VDD _00867_ sky130_fd_sc_hd__inv_1
X_06541_ _00866_ _00867_ VSS VSS VDD VDD _00868_ sky130_fd_sc_hd__nand2_1
X_06542_ _00865_ _00868_ VSS VSS VDD VDD _00869_ sky130_fd_sc_hd__nand2_1
X_06543_ _00853_ _00869_ VSS VSS VDD VDD _00870_ sky130_fd_sc_hd__nand2_1
X_06544_ _00851_ _00847_ VSS VSS VDD VDD _00871_ sky130_fd_sc_hd__nand2_1
X_06545_ _00870_ _00871_ VSS VSS VDD VDD _00872_ sky130_fd_sc_hd__nand2_1
X_06546_ _00824_ _00830_ _00872_ VSS VSS VDD VDD _00873_ sky130_fd_sc_hd__nand3_1
X_06547_ _00796_ _00798_ _00829_ VSS VSS VDD VDD _00874_ sky130_fd_sc_hd__nand3_1
X_06548_ _00825_ _00826_ _00823_ VSS VSS VDD VDD _00875_ sky130_fd_sc_hd__nand3_1
X_06549_ _00872_ VSS VSS VDD VDD _00876_ sky130_fd_sc_hd__inv_2
X_06550_ _00874_ _00875_ _00876_ VSS VSS VDD VDD _00877_ sky130_fd_sc_hd__nand3_1
X_06551_ _00861_ _00864_ _00860_ VSS VSS VDD VDD _00878_ sky130_fd_sc_hd__a21oi_1
X_06552_ _00878_ VSS VSS VDD VDD _00879_ sky130_fd_sc_hd__inv_1
X_06553_ _00873_ _00877_ _00879_ VSS VSS VDD VDD _00880_ sky130_fd_sc_hd__nand3_2
X_06554_ _00875_ _00874_ _00872_ VSS VSS VDD VDD _00881_ sky130_fd_sc_hd__nand3_1
X_06555_ _00824_ _00830_ _00876_ VSS VSS VDD VDD _00882_ sky130_fd_sc_hd__nand3_1
X_06556_ _00881_ _00882_ _00878_ VSS VSS VDD VDD _00883_ sky130_fd_sc_hd__nand3_1
X_06557_ _00880_ _00883_ VSS VSS VDD VDD _00884_ sky130_fd_sc_hd__nand2_1
X_06558_ _00835_ _00846_ VSS VSS VDD VDD _00885_ sky130_fd_sc_hd__nand2_1
X_06559_ _00871_ _00885_ VSS VSS VDD VDD _00886_ sky130_fd_sc_hd__nand2_1
X_06560_ _00860_ _00862_ _00867_ VSS VSS VDD VDD _00887_ sky130_fd_sc_hd__o21ai_0
X_06561_ _00866_ _00864_ VSS VSS VDD VDD _00888_ sky130_fd_sc_hd__nand2_1
X_06562_ _00887_ _00888_ VSS VSS VDD VDD _00889_ sky130_fd_sc_hd__nand2_1
X_06563_ _00886_ _00889_ VSS VSS VDD VDD _00890_ sky130_fd_sc_hd__nand2_1
X_06564_ net1 net27 VSS VSS VDD VDD _00891_ sky130_fd_sc_hd__nand2_1
X_06565_ _00857_ _00891_ VSS VSS VDD VDD _00892_ sky130_fd_sc_hd__nand2_1
X_06566_ net9 net25 VSS VSS VDD VDD _00893_ sky130_fd_sc_hd__nand2_1
X_06567_ _00893_ VSS VSS VDD VDD _00894_ sky130_fd_sc_hd__inv_1
X_06568_ net1 net26 VSS VSS VDD VDD _00895_ sky130_fd_sc_hd__nand2_1
X_06569_ _00836_ _00895_ VSS VSS VDD VDD _00896_ sky130_fd_sc_hd__nor2_1
X_06570_ _00892_ _00894_ _00896_ VSS VSS VDD VDD _00897_ sky130_fd_sc_hd__a21oi_1
X_06571_ _00897_ VSS VSS VDD VDD _00898_ sky130_fd_sc_hd__inv_1
X_06572_ net11 net24 VSS VSS VDD VDD _00899_ sky130_fd_sc_hd__nand2_1
X_06573_ _00818_ _00899_ VSS VSS VDD VDD _00900_ sky130_fd_sc_hd__nand2_1
X_06574_ _00867_ _00900_ VSS VSS VDD VDD _00901_ sky130_fd_sc_hd__nand2_1
X_06575_ _00901_ VSS VSS VDD VDD _00902_ sky130_fd_sc_hd__inv_1
X_06576_ _00898_ _00902_ VSS VSS VDD VDD _00903_ sky130_fd_sc_hd__nand2_1
X_06577_ _00897_ _00901_ VSS VSS VDD VDD _00904_ sky130_fd_sc_hd__nand2_1
X_06578_ _00903_ _00904_ VSS VSS VDD VDD _00905_ sky130_fd_sc_hd__nand2_1
X_06579_ net10 net17 VSS VSS VDD VDD _00906_ sky130_fd_sc_hd__nand2_1
X_06580_ _00899_ _00906_ VSS VSS VDD VDD _00907_ sky130_fd_sc_hd__nor2_2
X_06581_ _00907_ VSS VSS VDD VDD _00908_ sky130_fd_sc_hd__inv_1
X_06582_ _00905_ _00908_ VSS VSS VDD VDD _00909_ sky130_fd_sc_hd__nand2_1
X_06583_ _00903_ _00907_ _00904_ VSS VSS VDD VDD _00910_ sky130_fd_sc_hd__nand3_1
X_06584_ _00842_ _00845_ VSS VSS VDD VDD _00911_ sky130_fd_sc_hd__nand2_1
X_06585_ _00911_ _00843_ VSS VSS VDD VDD _00912_ sky130_fd_sc_hd__nand2_1
X_06586_ _00842_ _00746_ _00845_ VSS VSS VDD VDD _00913_ sky130_fd_sc_hd__nand3_1
X_06587_ _00912_ _00913_ VSS VSS VDD VDD _00914_ sky130_fd_sc_hd__nand2_1
X_06588_ _00909_ _00910_ _00914_ VSS VSS VDD VDD _00915_ sky130_fd_sc_hd__nand3_1
X_06589_ _00915_ VSS VSS VDD VDD _00916_ sky130_fd_sc_hd__inv_1
X_06590_ _00870_ _00890_ _00916_ VSS VSS VDD VDD _00917_ sky130_fd_sc_hd__nand3_1
X_06591_ _00886_ _00869_ VSS VSS VDD VDD _00918_ sky130_fd_sc_hd__nand2_1
X_06592_ _00853_ _00889_ VSS VSS VDD VDD _00919_ sky130_fd_sc_hd__nand2_1
X_06593_ _00918_ _00919_ _00915_ VSS VSS VDD VDD _00920_ sky130_fd_sc_hd__nand3_1
X_06594_ _00910_ _00903_ VSS VSS VDD VDD _00921_ sky130_fd_sc_hd__nand2_1
X_06595_ _00917_ _00920_ _00921_ VSS VSS VDD VDD _00922_ sky130_fd_sc_hd__nand3_1
X_06596_ _00922_ _00917_ VSS VSS VDD VDD _00923_ sky130_fd_sc_hd__nand2_1
X_06597_ _00884_ _00923_ VSS VSS VDD VDD _00924_ sky130_fd_sc_hd__nand2_1
X_06598_ _00923_ VSS VSS VDD VDD _00925_ sky130_fd_sc_hd__inv_1
X_06599_ _00880_ _00883_ _00925_ VSS VSS VDD VDD _00926_ sky130_fd_sc_hd__nand3_1
X_06600_ _00924_ _00926_ VSS VSS VDD VDD _00927_ sky130_fd_sc_hd__nand2_2
X_06601_ _00917_ _00920_ VSS VSS VDD VDD _00928_ sky130_fd_sc_hd__nand2_1
X_06602_ _00921_ VSS VSS VDD VDD _00929_ sky130_fd_sc_hd__inv_1
X_06603_ _00928_ _00929_ VSS VSS VDD VDD _00930_ sky130_fd_sc_hd__nand2_1
X_06604_ _00930_ _00922_ VSS VSS VDD VDD _00931_ sky130_fd_sc_hd__nand2_1
X_06605_ _00905_ _00907_ VSS VSS VDD VDD _00932_ sky130_fd_sc_hd__nand2_1
X_06606_ _00911_ _00746_ VSS VSS VDD VDD _00933_ sky130_fd_sc_hd__nand2_1
X_06607_ _00933_ _00846_ VSS VSS VDD VDD _00934_ sky130_fd_sc_hd__nand2_1
X_06608_ _00903_ _00908_ _00904_ VSS VSS VDD VDD _00935_ sky130_fd_sc_hd__nand3_1
X_06609_ _00932_ _00934_ _00935_ VSS VSS VDD VDD _00936_ sky130_fd_sc_hd__nand3_1
X_06610_ _00915_ _00936_ VSS VSS VDD VDD _00937_ sky130_fd_sc_hd__nand2_1
X_06611_ _00892_ VSS VSS VDD VDD _00938_ sky130_fd_sc_hd__inv_1
X_06612_ _00896_ _00938_ VSS VSS VDD VDD _00939_ sky130_fd_sc_hd__nor2_1
X_06613_ _00893_ _00939_ VSS VSS VDD VDD _00940_ sky130_fd_sc_hd__xor2_1
X_06614_ net10 net24 VSS VSS VDD VDD _00941_ sky130_fd_sc_hd__nand2_1
X_06615_ _00863_ _00941_ VSS VSS VDD VDD _00942_ sky130_fd_sc_hd__nand2_1
X_06616_ _00908_ _00942_ VSS VSS VDD VDD _00943_ sky130_fd_sc_hd__nand2_1
X_06617_ net1 net25 VSS VSS VDD VDD _00944_ sky130_fd_sc_hd__nand2_1
X_06618_ _00857_ _00944_ VSS VSS VDD VDD _00945_ sky130_fd_sc_hd__nor2_1
X_06619_ _00945_ VSS VSS VDD VDD _00946_ sky130_fd_sc_hd__inv_1
X_06620_ _00943_ _00946_ VSS VSS VDD VDD _00947_ sky130_fd_sc_hd__nand2_1
X_06621_ _00908_ _00945_ _00942_ VSS VSS VDD VDD _00948_ sky130_fd_sc_hd__nand3_1
X_06622_ _00947_ _00948_ VSS VSS VDD VDD _00949_ sky130_fd_sc_hd__nand2_1
X_06623_ net9 net17 VSS VSS VDD VDD _00950_ sky130_fd_sc_hd__nand2_1
X_06624_ _00950_ VSS VSS VDD VDD _00951_ sky130_fd_sc_hd__inv_1
X_06625_ _00951_ net10 net24 VSS VSS VDD VDD _00952_ sky130_fd_sc_hd__nand3_1
X_06626_ _00949_ _00952_ VSS VSS VDD VDD _00953_ sky130_fd_sc_hd__nand2_1
X_06627_ _00952_ _00947_ _00948_ VSS VSS VDD VDD _00954_ sky130_fd_sc_hd__nand3b_1
X_06628_ _00953_ _00954_ VSS VSS VDD VDD _00955_ sky130_fd_sc_hd__nand2_1
X_06629_ _00940_ _00955_ VSS VSS VDD VDD _00956_ sky130_fd_sc_hd__nor2_2
X_06630_ _00956_ VSS VSS VDD VDD _00957_ sky130_fd_sc_hd__inv_1
X_06631_ _00937_ _00957_ VSS VSS VDD VDD _00958_ sky130_fd_sc_hd__nand2_1
X_06632_ _00954_ _00948_ VSS VSS VDD VDD _00959_ sky130_fd_sc_hd__nand2_1
X_06633_ _00909_ _00910_ _00934_ VSS VSS VDD VDD _00960_ sky130_fd_sc_hd__nand3_1
X_06634_ _00932_ _00914_ _00935_ VSS VSS VDD VDD _00961_ sky130_fd_sc_hd__nand3_1
X_06635_ _00960_ _00961_ VSS VSS VDD VDD _00962_ sky130_fd_sc_hd__nand2_1
X_06636_ _00962_ _00956_ VSS VSS VDD VDD _00963_ sky130_fd_sc_hd__nand2_1
X_06637_ _00963_ VSS VSS VDD VDD _00964_ sky130_fd_sc_hd__inv_1
X_06638_ _00958_ _00959_ _00964_ VSS VSS VDD VDD _00965_ sky130_fd_sc_hd__a21oi_2
X_06639_ _00965_ VSS VSS VDD VDD _00966_ sky130_fd_sc_hd__inv_1
X_06640_ _00931_ _00966_ VSS VSS VDD VDD _00967_ sky130_fd_sc_hd__nand2_1
X_06641_ _00930_ _00965_ _00922_ VSS VSS VDD VDD _00968_ sky130_fd_sc_hd__nand3_1
X_06642_ _00967_ _00968_ VSS VSS VDD VDD _00969_ sky130_fd_sc_hd__nand2_1
X_06643_ _00963_ _00958_ _00959_ VSS VSS VDD VDD _00970_ sky130_fd_sc_hd__nand3_1
X_06644_ _00937_ _00956_ VSS VSS VDD VDD _00971_ sky130_fd_sc_hd__nand2_1
X_06645_ _00962_ _00957_ VSS VSS VDD VDD _00972_ sky130_fd_sc_hd__nand2_1
X_06646_ _00959_ VSS VSS VDD VDD _00973_ sky130_fd_sc_hd__inv_1
X_06647_ _00971_ _00972_ _00973_ VSS VSS VDD VDD _00974_ sky130_fd_sc_hd__nand3_1
X_06648_ _00970_ _00974_ VSS VSS VDD VDD _00975_ sky130_fd_sc_hd__nand2_1
X_06649_ _00955_ _00940_ VSS VSS VDD VDD _00976_ sky130_fd_sc_hd__nand2_1
X_06650_ net8 net25 VSS VSS VDD VDD _00977_ sky130_fd_sc_hd__nand2_1
X_06651_ _00895_ _00977_ VSS VSS VDD VDD _00978_ sky130_fd_sc_hd__nand2_1
X_06652_ _00946_ _00978_ VSS VSS VDD VDD _00979_ sky130_fd_sc_hd__nand2_1
X_06653_ net9 net24 VSS VSS VDD VDD _00980_ sky130_fd_sc_hd__nand2_1
X_06654_ _00906_ _00980_ VSS VSS VDD VDD _00981_ sky130_fd_sc_hd__nand2_1
X_06655_ _00952_ _00981_ VSS VSS VDD VDD _00982_ sky130_fd_sc_hd__nand2_1
X_06656_ net8 net24 VSS VSS VDD VDD _00983_ sky130_fd_sc_hd__nand2_1
X_06657_ _00983_ VSS VSS VDD VDD _00984_ sky130_fd_sc_hd__inv_1
X_06658_ _00951_ _00984_ VSS VSS VDD VDD _00985_ sky130_fd_sc_hd__nand2_1
X_06659_ _00982_ _00985_ VSS VSS VDD VDD _00986_ sky130_fd_sc_hd__nand2_1
X_06660_ _00981_ _00951_ _00984_ _00941_ VSS VSS VDD VDD _00987_
+ sky130_fd_sc_hd__nand4_1
X_06661_ _00986_ _00987_ VSS VSS VDD VDD _00988_ sky130_fd_sc_hd__nand2_1
X_06662_ _00979_ _00988_ _00987_ VSS VSS VDD VDD _00989_ sky130_fd_sc_hd__o21ai_0
X_06663_ _00957_ _00976_ _00989_ VSS VSS VDD VDD _00990_ sky130_fd_sc_hd__nand3_1
X_06664_ _00975_ _00990_ VSS VSS VDD VDD _00991_ sky130_fd_sc_hd__nand2_1
X_06665_ _00979_ _00988_ VSS VSS VDD VDD _00992_ sky130_fd_sc_hd__xnor2_1
X_06666_ _00950_ _00983_ VSS VSS VDD VDD _00993_ sky130_fd_sc_hd__nand2_1
X_06667_ _00985_ _00993_ VSS VSS VDD VDD _00994_ sky130_fd_sc_hd__nand2_1
X_06668_ net1 net17 VSS VSS VDD VDD _00995_ sky130_fd_sc_hd__nand2_1
X_06669_ _00983_ _00995_ VSS VSS VDD VDD _00996_ sky130_fd_sc_hd__nor2_1
X_06670_ _00996_ VSS VSS VDD VDD _00997_ sky130_fd_sc_hd__inv_1
X_06671_ _00994_ _00997_ VSS VSS VDD VDD _00998_ sky130_fd_sc_hd__nand2_1
X_06672_ _00985_ _00996_ _00993_ VSS VSS VDD VDD _00999_ sky130_fd_sc_hd__nand3_1
X_06673_ _00998_ _00999_ VSS VSS VDD VDD _01000_ sky130_fd_sc_hd__nand2_1
X_06674_ _00944_ _01000_ VSS VSS VDD VDD _01001_ sky130_fd_sc_hd__nor2_1
X_06675_ _01001_ VSS VSS VDD VDD _01002_ sky130_fd_sc_hd__inv_1
X_06676_ _01002_ _00999_ VSS VSS VDD VDD _01003_ sky130_fd_sc_hd__nand2_1
X_06677_ _00992_ _01003_ VSS VSS VDD VDD _01004_ sky130_fd_sc_hd__nand2b_1
X_06678_ _00957_ _00976_ VSS VSS VDD VDD _01005_ sky130_fd_sc_hd__nand2_1
X_06679_ _00989_ VSS VSS VDD VDD _01006_ sky130_fd_sc_hd__inv_1
X_06680_ _01005_ _01006_ VSS VSS VDD VDD _01007_ sky130_fd_sc_hd__nand2_1
X_06681_ _01004_ _00990_ _01007_ VSS VSS VDD VDD _01008_ sky130_fd_sc_hd__nand3b_1
X_06682_ _01008_ VSS VSS VDD VDD _01009_ sky130_fd_sc_hd__inv_2
X_06683_ _00990_ _00975_ VSS VSS VDD VDD _01010_ sky130_fd_sc_hd__nor2_1
X_06684_ _00991_ _01009_ _01010_ VSS VSS VDD VDD _01011_ sky130_fd_sc_hd__a21oi_1
X_06685_ _01011_ VSS VSS VDD VDD _01012_ sky130_fd_sc_hd__inv_1
X_06686_ _00927_ _00969_ _01012_ VSS VSS VDD VDD _01013_ sky130_fd_sc_hd__nand3_1
X_06687_ _00884_ _00925_ VSS VSS VDD VDD _01014_ sky130_fd_sc_hd__nand2_1
X_06688_ _00965_ _00931_ VSS VSS VDD VDD _01015_ sky130_fd_sc_hd__nor2_1
X_06689_ _00880_ _00883_ _00923_ VSS VSS VDD VDD _01016_ sky130_fd_sc_hd__nand3_1
X_06690_ _01016_ VSS VSS VDD VDD _01017_ sky130_fd_sc_hd__inv_1
X_06691_ _01014_ _01015_ _01017_ VSS VSS VDD VDD _01018_ sky130_fd_sc_hd__a21oi_1
X_06692_ _01013_ _01018_ VSS VSS VDD VDD _01019_ sky130_fd_sc_hd__nand2_1
X_06693_ net9 _00729_ VSS VSS VDD VDD _01020_ sky130_fd_sc_hd__nor2_1
X_06694_ net10 net29 VSS VSS VDD VDD _01021_ sky130_fd_sc_hd__nand2_1
X_06695_ _01021_ VSS VSS VDD VDD _01022_ sky130_fd_sc_hd__inv_1
X_06696_ _01020_ _01022_ VSS VSS VDD VDD _01023_ sky130_fd_sc_hd__nand2_1
X_06697_ net9 VSS VSS VDD VDD _01024_ sky130_fd_sc_hd__inv_1
X_06698_ _01024_ net30 VSS VSS VDD VDD _01025_ sky130_fd_sc_hd__nand2_1
X_06699_ _01025_ _01021_ VSS VSS VDD VDD _01026_ sky130_fd_sc_hd__nand2_1
X_06700_ _01023_ _01026_ VSS VSS VDD VDD _01027_ sky130_fd_sc_hd__nand2_1
X_06701_ net11 net28 VSS VSS VDD VDD _01028_ sky130_fd_sc_hd__nand2_1
X_06702_ _01028_ VSS VSS VDD VDD _01029_ sky130_fd_sc_hd__inv_1
X_06703_ _01027_ _01029_ VSS VSS VDD VDD _01030_ sky130_fd_sc_hd__nand2_1
X_06704_ _01023_ _01026_ _01028_ VSS VSS VDD VDD _01031_ sky130_fd_sc_hd__nand3_1
X_06705_ _01030_ _01031_ VSS VSS VDD VDD _01032_ sky130_fd_sc_hd__nand2_1
X_06706_ net10 net28 VSS VSS VDD VDD _01033_ sky130_fd_sc_hd__nand2_1
X_06707_ _01033_ VSS VSS VDD VDD _01034_ sky130_fd_sc_hd__inv_1
X_06708_ net8 VSS VSS VDD VDD _01035_ sky130_fd_sc_hd__inv_1
X_06709_ _01035_ net30 VSS VSS VDD VDD _01036_ sky130_fd_sc_hd__nand2_1
X_06710_ net9 net29 VSS VSS VDD VDD _01037_ sky130_fd_sc_hd__nand2_1
X_06711_ _01036_ _01037_ VSS VSS VDD VDD _01038_ sky130_fd_sc_hd__nand2_1
X_06712_ net8 _00729_ VSS VSS VDD VDD _01039_ sky130_fd_sc_hd__nor2_2
X_06713_ _01037_ VSS VSS VDD VDD _01040_ sky130_fd_sc_hd__inv_1
X_06714_ _01039_ _01040_ VSS VSS VDD VDD _01041_ sky130_fd_sc_hd__nand2_1
X_06715_ _01034_ _01038_ _01041_ VSS VSS VDD VDD _01042_ sky130_fd_sc_hd__a21boi_1
X_06716_ _01032_ _01042_ VSS VSS VDD VDD _01043_ sky130_fd_sc_hd__nand2_1
X_06717_ _01027_ _01028_ VSS VSS VDD VDD _01044_ sky130_fd_sc_hd__nand2_1
X_06718_ _01023_ _01026_ _01029_ VSS VSS VDD VDD _01045_ sky130_fd_sc_hd__nand3_1
X_06719_ _01044_ _01045_ VSS VSS VDD VDD _01046_ sky130_fd_sc_hd__nand2_1
X_06720_ _01041_ _01038_ _01034_ VSS VSS VDD VDD _01047_ sky130_fd_sc_hd__nand3_1
X_06721_ _01047_ _01041_ VSS VSS VDD VDD _01048_ sky130_fd_sc_hd__nand2_1
X_06722_ _01046_ _01048_ VSS VSS VDD VDD _01049_ sky130_fd_sc_hd__nand2_1
X_06723_ net12 net13 net26 net27 VSS VSS VDD VDD _01050_ sky130_fd_sc_hd__nand4_1
X_06724_ net13 net26 VSS VSS VDD VDD _01051_ sky130_fd_sc_hd__nand2_1
X_06725_ net12 net27 VSS VSS VDD VDD _01052_ sky130_fd_sc_hd__nand2_1
X_06726_ _01051_ _01052_ VSS VSS VDD VDD _01053_ sky130_fd_sc_hd__nand2_1
X_06727_ _01050_ _01053_ VSS VSS VDD VDD _01054_ sky130_fd_sc_hd__nand2_1
X_06728_ net14 net25 VSS VSS VDD VDD _01055_ sky130_fd_sc_hd__nand2_2
X_06729_ _01054_ _01055_ VSS VSS VDD VDD _01056_ sky130_fd_sc_hd__nand2_1
X_06730_ _01055_ VSS VSS VDD VDD _01057_ sky130_fd_sc_hd__inv_2
X_06731_ _01050_ _01057_ _01053_ VSS VSS VDD VDD _01058_ sky130_fd_sc_hd__nand3_1
X_06732_ _01056_ _01058_ VSS VSS VDD VDD _01059_ sky130_fd_sc_hd__nand2_1
X_06733_ _01059_ VSS VSS VDD VDD _01060_ sky130_fd_sc_hd__inv_1
X_06734_ _01043_ _01049_ _01060_ VSS VSS VDD VDD _01061_ sky130_fd_sc_hd__nand3_1
X_06735_ _01046_ _01042_ VSS VSS VDD VDD _01062_ sky130_fd_sc_hd__nand2_1
X_06736_ _01032_ _01048_ VSS VSS VDD VDD _01063_ sky130_fd_sc_hd__nand2_1
X_06737_ _01062_ _01063_ _01059_ VSS VSS VDD VDD _01064_ sky130_fd_sc_hd__nand3_1
X_06738_ _01061_ _01064_ VSS VSS VDD VDD _01065_ sky130_fd_sc_hd__nand2_1
X_06739_ net11 net12 net26 net27 VSS VSS VDD VDD _01066_ sky130_fd_sc_hd__nand4_1
X_06740_ net12 net26 VSS VSS VDD VDD _01067_ sky130_fd_sc_hd__nand2_1
X_06741_ net11 net27 VSS VSS VDD VDD _01068_ sky130_fd_sc_hd__nand2_1
X_06742_ _01067_ _01068_ VSS VSS VDD VDD _01069_ sky130_fd_sc_hd__nand2_1
X_06743_ _01066_ _01069_ VSS VSS VDD VDD _01070_ sky130_fd_sc_hd__nand2_1
X_06744_ net13 net25 VSS VSS VDD VDD _01071_ sky130_fd_sc_hd__nand2_1
X_06745_ _01070_ _01071_ VSS VSS VDD VDD _01072_ sky130_fd_sc_hd__nand2_1
X_06746_ _01071_ VSS VSS VDD VDD _01073_ sky130_fd_sc_hd__inv_1
X_06747_ _01066_ _01073_ _01069_ VSS VSS VDD VDD _01074_ sky130_fd_sc_hd__nand3_1
X_06748_ _01072_ _01074_ VSS VSS VDD VDD _01075_ sky130_fd_sc_hd__nand2_1
X_06749_ _01075_ VSS VSS VDD VDD _01076_ sky130_fd_sc_hd__inv_1
X_06750_ _01041_ _01038_ VSS VSS VDD VDD _01077_ sky130_fd_sc_hd__nand2_1
X_06751_ _01077_ _01033_ VSS VSS VDD VDD _01078_ sky130_fd_sc_hd__nand2_1
X_06752_ _01078_ _01047_ VSS VSS VDD VDD _01079_ sky130_fd_sc_hd__nand2_1
X_06753_ _00742_ _00737_ _00734_ VSS VSS VDD VDD _01080_ sky130_fd_sc_hd__a21boi_1
X_06754_ _01079_ _01080_ VSS VSS VDD VDD _01081_ sky130_fd_sc_hd__nand2_1
X_06755_ _01077_ _01034_ VSS VSS VDD VDD _01082_ sky130_fd_sc_hd__nand2_1
X_06756_ _01041_ _01038_ _01033_ VSS VSS VDD VDD _01083_ sky130_fd_sc_hd__nand3_1
X_06757_ _01082_ _01083_ VSS VSS VDD VDD _01084_ sky130_fd_sc_hd__nand2_1
X_06758_ _00750_ _00734_ VSS VSS VDD VDD _01085_ sky130_fd_sc_hd__nand2_1
X_06759_ _01084_ _01085_ VSS VSS VDD VDD _01086_ sky130_fd_sc_hd__nand2_1
X_06760_ _01076_ _01081_ _01086_ VSS VSS VDD VDD _01087_ sky130_fd_sc_hd__a21boi_1
X_06761_ _01065_ _01087_ VSS VSS VDD VDD _01088_ sky130_fd_sc_hd__nand2_1
X_06762_ _01062_ _01063_ _01060_ VSS VSS VDD VDD _01089_ sky130_fd_sc_hd__nand3_1
X_06763_ _01043_ _01049_ _01059_ VSS VSS VDD VDD _01090_ sky130_fd_sc_hd__nand3_1
X_06764_ _01089_ _01090_ VSS VSS VDD VDD _01091_ sky130_fd_sc_hd__nand2_1
X_06765_ _01081_ _01086_ _01076_ VSS VSS VDD VDD _01092_ sky130_fd_sc_hd__nand3_1
X_06766_ _01092_ _01086_ VSS VSS VDD VDD _01093_ sky130_fd_sc_hd__nand2_1
X_06767_ _01091_ _01093_ VSS VSS VDD VDD _01094_ sky130_fd_sc_hd__nand2_1
X_06768_ _00801_ _00805_ VSS VSS VDD VDD _01095_ sky130_fd_sc_hd__nand2_2
X_06769_ _01095_ VSS VSS VDD VDD _01096_ sky130_fd_sc_hd__inv_2
X_06770_ _01074_ _01066_ VSS VSS VDD VDD _01097_ sky130_fd_sc_hd__nand2_1
X_06771_ _01097_ VSS VSS VDD VDD _01098_ sky130_fd_sc_hd__inv_1
X_06772_ _01096_ _01098_ VSS VSS VDD VDD _01099_ sky130_fd_sc_hd__nor2_2
X_06773_ _01099_ VSS VSS VDD VDD _01100_ sky130_fd_sc_hd__inv_1
X_06774_ _01098_ _01096_ VSS VSS VDD VDD _01101_ sky130_fd_sc_hd__nand2_1
X_06775_ _01100_ _01101_ VSS VSS VDD VDD _01102_ sky130_fd_sc_hd__nand2_1
X_06776_ _01102_ VSS VSS VDD VDD _01103_ sky130_fd_sc_hd__inv_2
X_06777_ _01088_ _01094_ _01103_ VSS VSS VDD VDD _01104_ sky130_fd_sc_hd__nand3_1
X_06778_ _01091_ _01087_ VSS VSS VDD VDD _01105_ sky130_fd_sc_hd__nand2_1
X_06779_ _01065_ _01093_ VSS VSS VDD VDD _01106_ sky130_fd_sc_hd__nand2_1
X_06780_ _01105_ _01106_ _01102_ VSS VSS VDD VDD _01107_ sky130_fd_sc_hd__nand3_1
X_06781_ _01104_ _01107_ VSS VSS VDD VDD _01108_ sky130_fd_sc_hd__nand2_1
X_06782_ _00805_ _00806_ VSS VSS VDD VDD _01109_ sky130_fd_sc_hd__nor2_1
X_06783_ _00807_ net30 _01109_ VSS VSS VDD VDD _01110_ sky130_fd_sc_hd__a21oi_1
X_06784_ _01110_ VSS VSS VDD VDD _01111_ sky130_fd_sc_hd__inv_1
X_06785_ net14 net17 net24 VSS VSS VDD VDD _01112_ sky130_fd_sc_hd__nand3_1
X_06786_ _01095_ _01112_ VSS VSS VDD VDD _01113_ sky130_fd_sc_hd__nand2_1
X_06787_ _00757_ VSS VSS VDD VDD _01114_ sky130_fd_sc_hd__inv_1
X_06788_ _01068_ _00780_ VSS VSS VDD VDD _01115_ sky130_fd_sc_hd__nor2_1
X_06789_ _00766_ _01114_ _01115_ VSS VSS VDD VDD _01116_ sky130_fd_sc_hd__a21oi_1
X_06790_ _01113_ _01116_ VSS VSS VDD VDD _01117_ sky130_fd_sc_hd__nor2_1
X_06791_ _01116_ _01113_ VSS VSS VDD VDD _01118_ sky130_fd_sc_hd__nand2_1
X_06792_ _01118_ VSS VSS VDD VDD _01119_ sky130_fd_sc_hd__inv_1
X_06793_ _01117_ _01119_ VSS VSS VDD VDD _01120_ sky130_fd_sc_hd__nor2_1
X_06794_ _01111_ _01120_ VSS VSS VDD VDD _01121_ sky130_fd_sc_hd__nor2_1
X_06795_ _01120_ _01111_ VSS VSS VDD VDD _01122_ sky130_fd_sc_hd__nand2_1
X_06796_ _01122_ VSS VSS VDD VDD _01123_ sky130_fd_sc_hd__inv_1
X_06797_ _01121_ _01123_ VSS VSS VDD VDD _01124_ sky130_fd_sc_hd__nor2_1
X_06798_ _01084_ _01080_ VSS VSS VDD VDD _01125_ sky130_fd_sc_hd__nand2_1
X_06799_ _01079_ _01085_ VSS VSS VDD VDD _01126_ sky130_fd_sc_hd__nand2_1
X_06800_ _01125_ _01126_ _01075_ VSS VSS VDD VDD _01127_ sky130_fd_sc_hd__nand3_1
X_06801_ _01092_ _01127_ VSS VSS VDD VDD _01128_ sky130_fd_sc_hd__nand2_1
X_06802_ _00774_ _00753_ _00748_ VSS VSS VDD VDD _01129_ sky130_fd_sc_hd__a21boi_1
X_06803_ _01128_ _01129_ VSS VSS VDD VDD _01130_ sky130_fd_sc_hd__nand2_1
X_06804_ _01125_ _01126_ _01076_ VSS VSS VDD VDD _01131_ sky130_fd_sc_hd__nand3_1
X_06805_ _01081_ _01086_ _01075_ VSS VSS VDD VDD _01132_ sky130_fd_sc_hd__nand3_1
X_06806_ _01131_ _01132_ VSS VSS VDD VDD _01133_ sky130_fd_sc_hd__nand2_1
X_06807_ _00775_ _00748_ VSS VSS VDD VDD _01134_ sky130_fd_sc_hd__nand2_1
X_06808_ _01133_ _01134_ VSS VSS VDD VDD _01135_ sky130_fd_sc_hd__nand2_1
X_06809_ _01124_ _01130_ _01135_ VSS VSS VDD VDD _01136_ sky130_fd_sc_hd__a21boi_1
X_06810_ _01108_ _01136_ VSS VSS VDD VDD _01137_ sky130_fd_sc_hd__nand2_1
X_06811_ _01105_ _01106_ _01103_ VSS VSS VDD VDD _01138_ sky130_fd_sc_hd__nand3_1
X_06812_ _01088_ _01094_ _01102_ VSS VSS VDD VDD _01139_ sky130_fd_sc_hd__nand3_1
X_06813_ _01138_ _01139_ VSS VSS VDD VDD _01140_ sky130_fd_sc_hd__nand2_1
X_06814_ _01130_ _01135_ _01124_ VSS VSS VDD VDD _01141_ sky130_fd_sc_hd__nand3_1
X_06815_ _01141_ _01135_ VSS VSS VDD VDD _01142_ sky130_fd_sc_hd__nand2_1
X_06816_ _01140_ _01142_ VSS VSS VDD VDD _01143_ sky130_fd_sc_hd__nand2_1
X_06817_ _01117_ _01123_ VSS VSS VDD VDD _01144_ sky130_fd_sc_hd__nor2_1
X_06818_ _01144_ VSS VSS VDD VDD _01145_ sky130_fd_sc_hd__inv_1
X_06819_ _01137_ _01143_ _01145_ VSS VSS VDD VDD _01146_ sky130_fd_sc_hd__nand3_1
X_06820_ _01140_ _01136_ VSS VSS VDD VDD _01147_ sky130_fd_sc_hd__nand2_1
X_06821_ _01108_ _01142_ VSS VSS VDD VDD _01148_ sky130_fd_sc_hd__nand2_1
X_06822_ _01147_ _01148_ _01144_ VSS VSS VDD VDD _01149_ sky130_fd_sc_hd__nand3_1
X_06823_ _01146_ _01149_ VSS VSS VDD VDD _01150_ sky130_fd_sc_hd__nand2_1
X_06824_ _00828_ _00816_ VSS VSS VDD VDD _01151_ sky130_fd_sc_hd__nand2_1
X_06825_ _01133_ _01129_ VSS VSS VDD VDD _01152_ sky130_fd_sc_hd__nand2_1
X_06826_ _01128_ _01134_ VSS VSS VDD VDD _01153_ sky130_fd_sc_hd__nand2_1
X_06827_ _01121_ VSS VSS VDD VDD _01154_ sky130_fd_sc_hd__inv_1
X_06828_ _01154_ _01122_ VSS VSS VDD VDD _01155_ sky130_fd_sc_hd__nand2_1
X_06829_ _01152_ _01153_ _01155_ VSS VSS VDD VDD _01156_ sky130_fd_sc_hd__nand3_1
X_06830_ _01141_ _01156_ VSS VSS VDD VDD _01157_ sky130_fd_sc_hd__nand2_1
X_06831_ _00796_ _00823_ _00798_ VSS VSS VDD VDD _01158_ sky130_fd_sc_hd__a21boi_1
X_06832_ _01157_ _01158_ VSS VSS VDD VDD _01159_ sky130_fd_sc_hd__nand2_1
X_06833_ _01152_ _01153_ _01124_ VSS VSS VDD VDD _01160_ sky130_fd_sc_hd__nand3_1
X_06834_ _01130_ _01135_ _01155_ VSS VSS VDD VDD _01161_ sky130_fd_sc_hd__nand3_1
X_06835_ _01160_ _01161_ VSS VSS VDD VDD _01162_ sky130_fd_sc_hd__nand2_1
X_06836_ _00824_ _00798_ VSS VSS VDD VDD _01163_ sky130_fd_sc_hd__nand2_1
X_06837_ _01162_ _01163_ VSS VSS VDD VDD _01164_ sky130_fd_sc_hd__nand2_1
X_06838_ _01151_ _01159_ _01164_ VSS VSS VDD VDD _01165_ sky130_fd_sc_hd__a21boi_1
X_06839_ _01150_ _01165_ VSS VSS VDD VDD _01166_ sky130_fd_sc_hd__nand2_1
X_06840_ _01147_ _01148_ _01145_ VSS VSS VDD VDD _01167_ sky130_fd_sc_hd__nand3_1
X_06841_ _01137_ _01143_ _01144_ VSS VSS VDD VDD _01168_ sky130_fd_sc_hd__nand3_1
X_06842_ _01167_ _01168_ VSS VSS VDD VDD _01169_ sky130_fd_sc_hd__nand2_1
X_06843_ _01164_ _01159_ _01151_ VSS VSS VDD VDD _01170_ sky130_fd_sc_hd__nand3_1
X_06844_ _01170_ _01164_ VSS VSS VDD VDD _01171_ sky130_fd_sc_hd__nand2_1
X_06845_ _01169_ _01171_ VSS VSS VDD VDD _01172_ sky130_fd_sc_hd__nand2_1
X_06846_ _01166_ _01172_ VSS VSS VDD VDD _01173_ sky130_fd_sc_hd__nand2_2
X_06847_ _01157_ _01163_ VSS VSS VDD VDD _01174_ sky130_fd_sc_hd__nand2_1
X_06848_ _01162_ _01158_ VSS VSS VDD VDD _01175_ sky130_fd_sc_hd__nand2_1
X_06849_ _01151_ VSS VSS VDD VDD _01176_ sky130_fd_sc_hd__inv_1
X_06850_ _01174_ _01175_ _01176_ VSS VSS VDD VDD _01177_ sky130_fd_sc_hd__nand3_1
X_06851_ _01170_ _01177_ VSS VSS VDD VDD _01178_ sky130_fd_sc_hd__nand2_1
X_06852_ _00880_ _00873_ VSS VSS VDD VDD _01179_ sky130_fd_sc_hd__nand2_1
X_06853_ _01178_ _01179_ VSS VSS VDD VDD _01180_ sky130_fd_sc_hd__nand2_1
X_06854_ _01174_ _01175_ _01151_ VSS VSS VDD VDD _01181_ sky130_fd_sc_hd__nand3_1
X_06855_ _01164_ _01159_ _01176_ VSS VSS VDD VDD _01182_ sky130_fd_sc_hd__nand3_1
X_06856_ _01181_ _01182_ VSS VSS VDD VDD _01183_ sky130_fd_sc_hd__nand2_1
X_06857_ _00879_ _00877_ _00873_ VSS VSS VDD VDD _01184_ sky130_fd_sc_hd__a21boi_1
X_06858_ _01183_ _01184_ VSS VSS VDD VDD _01185_ sky130_fd_sc_hd__nand2_1
X_06859_ _01180_ _01185_ VSS VSS VDD VDD _01186_ sky130_fd_sc_hd__nand2_1
X_06860_ _01173_ _01186_ VSS VSS VDD VDD _01187_ sky130_fd_sc_hd__nand2_1
X_06861_ _01187_ VSS VSS VDD VDD _01188_ sky130_fd_sc_hd__inv_1
X_06862_ _01019_ _01188_ VSS VSS VDD VDD _01189_ sky130_fd_sc_hd__nand2_1
X_06863_ _01150_ _01171_ VSS VSS VDD VDD _01190_ sky130_fd_sc_hd__nand2_1
X_06864_ _01183_ _01179_ VSS VSS VDD VDD _01191_ sky130_fd_sc_hd__nand2_1
X_06865_ _01190_ _01191_ VSS VSS VDD VDD _01192_ sky130_fd_sc_hd__nand2_1
X_06866_ _01169_ _01165_ VSS VSS VDD VDD _01193_ sky130_fd_sc_hd__nand2_1
X_06867_ _01192_ _01193_ VSS VSS VDD VDD _01194_ sky130_fd_sc_hd__nand2_1
X_06868_ _01189_ _01194_ VSS VSS VDD VDD _01195_ sky130_fd_sc_hd__nand2_1
X_06869_ net10 _00729_ VSS VSS VDD VDD _01196_ sky130_fd_sc_hd__nor2_1
X_06870_ net11 net29 VSS VSS VDD VDD _01197_ sky130_fd_sc_hd__nand2_2
X_06871_ _01197_ VSS VSS VDD VDD _01198_ sky130_fd_sc_hd__inv_2
X_06872_ _01196_ _01198_ VSS VSS VDD VDD _01199_ sky130_fd_sc_hd__nand2_2
X_06873_ net10 VSS VSS VDD VDD _01200_ sky130_fd_sc_hd__inv_1
X_06874_ _01200_ net30 VSS VSS VDD VDD _01201_ sky130_fd_sc_hd__nand2_1
X_06875_ _01201_ _01197_ VSS VSS VDD VDD _01202_ sky130_fd_sc_hd__nand2_2
X_06876_ _01199_ _01202_ VSS VSS VDD VDD _01203_ sky130_fd_sc_hd__nand2_1
X_06877_ net12 net28 VSS VSS VDD VDD _01204_ sky130_fd_sc_hd__nand2_1
X_06878_ _01204_ VSS VSS VDD VDD _01205_ sky130_fd_sc_hd__inv_1
X_06879_ _01203_ _01205_ VSS VSS VDD VDD _01206_ sky130_fd_sc_hd__nand2_1
X_06880_ _01199_ _01202_ _01204_ VSS VSS VDD VDD _01207_ sky130_fd_sc_hd__nand3_1
X_06881_ _01206_ _01207_ VSS VSS VDD VDD _01208_ sky130_fd_sc_hd__nand2_1
X_06882_ _01029_ _01026_ _01023_ VSS VSS VDD VDD _01209_ sky130_fd_sc_hd__a21boi_0
X_06883_ _01208_ _01209_ VSS VSS VDD VDD _01210_ sky130_fd_sc_hd__nand2_1
X_06884_ _01203_ _01204_ VSS VSS VDD VDD _01211_ sky130_fd_sc_hd__nand2_1
X_06885_ _01199_ _01202_ _01205_ VSS VSS VDD VDD _01212_ sky130_fd_sc_hd__nand3_2
X_06886_ _01211_ _01212_ VSS VSS VDD VDD _01213_ sky130_fd_sc_hd__nand2_1
X_06887_ _01045_ _01023_ VSS VSS VDD VDD _01214_ sky130_fd_sc_hd__nand2_1
X_06888_ _01213_ _01214_ VSS VSS VDD VDD _01215_ sky130_fd_sc_hd__nand2_1
X_06889_ net14 net27 VSS VSS VDD VDD _01216_ sky130_fd_sc_hd__nand2_1
X_06890_ net14 net26 VSS VSS VDD VDD _01217_ sky130_fd_sc_hd__nand2_1
X_06891_ net13 net27 VSS VSS VDD VDD _01218_ sky130_fd_sc_hd__nand2_1
X_06892_ _01217_ _01218_ VSS VSS VDD VDD _01219_ sky130_fd_sc_hd__nand2_1
X_06893_ _01216_ _01051_ _01219_ VSS VSS VDD VDD _01220_ sky130_fd_sc_hd__o21ai_1
X_06894_ _01057_ _01220_ VSS VSS VDD VDD _01221_ sky130_fd_sc_hd__xor2_1
X_06895_ _01210_ _01215_ _01221_ VSS VSS VDD VDD _01222_ sky130_fd_sc_hd__nand3_1
X_06896_ _01213_ _01209_ VSS VSS VDD VDD _01223_ sky130_fd_sc_hd__nand2_1
X_06897_ _01208_ _01214_ VSS VSS VDD VDD _01224_ sky130_fd_sc_hd__nand2_2
X_06898_ _01055_ _01220_ VSS VSS VDD VDD _01225_ sky130_fd_sc_hd__xor2_1
X_06899_ _01223_ _01224_ _01225_ VSS VSS VDD VDD _01226_ sky130_fd_sc_hd__nand3_1
X_06900_ _01222_ _01226_ VSS VSS VDD VDD _01227_ sky130_fd_sc_hd__nand2_1
X_06901_ _01060_ _01062_ _01063_ VSS VSS VDD VDD _01228_ sky130_fd_sc_hd__a21boi_1
X_06902_ _01227_ _01228_ VSS VSS VDD VDD _01229_ sky130_fd_sc_hd__nand2_1
X_06903_ _01223_ _01224_ _01221_ VSS VSS VDD VDD _01230_ sky130_fd_sc_hd__nand3_1
X_06904_ _01210_ _01215_ _01225_ VSS VSS VDD VDD _01231_ sky130_fd_sc_hd__nand3_1
X_06905_ _01230_ _01231_ VSS VSS VDD VDD _01232_ sky130_fd_sc_hd__nand2_1
X_06906_ _01089_ _01063_ VSS VSS VDD VDD _01233_ sky130_fd_sc_hd__nand2_1
X_06907_ _01232_ _01233_ VSS VSS VDD VDD _01234_ sky130_fd_sc_hd__nand2_1
X_06908_ _01058_ _01050_ VSS VSS VDD VDD _01235_ sky130_fd_sc_hd__nand2_1
X_06909_ _01235_ VSS VSS VDD VDD _01236_ sky130_fd_sc_hd__inv_1
X_06910_ _01096_ _01236_ VSS VSS VDD VDD _01237_ sky130_fd_sc_hd__nor2_2
X_06911_ _01237_ VSS VSS VDD VDD _01238_ sky130_fd_sc_hd__inv_1
X_06912_ _01236_ _01096_ VSS VSS VDD VDD _01239_ sky130_fd_sc_hd__nand2_1
X_06913_ _01238_ _01239_ VSS VSS VDD VDD _01240_ sky130_fd_sc_hd__nand2_1
X_06914_ _01240_ VSS VSS VDD VDD _01241_ sky130_fd_sc_hd__inv_1
X_06915_ _01229_ _01234_ _01241_ VSS VSS VDD VDD _01242_ sky130_fd_sc_hd__nand3_1
X_06916_ _01242_ _01234_ VSS VSS VDD VDD _01243_ sky130_fd_sc_hd__nand2_1
X_06917_ _01243_ VSS VSS VDD VDD _01244_ sky130_fd_sc_hd__inv_1
X_06918_ _01226_ _01224_ VSS VSS VDD VDD _01245_ sky130_fd_sc_hd__nand2_1
X_06919_ _01245_ VSS VSS VDD VDD _01246_ sky130_fd_sc_hd__inv_2
X_06920_ _01212_ _01199_ VSS VSS VDD VDD _01247_ sky130_fd_sc_hd__nand2_1
X_06921_ _01247_ VSS VSS VDD VDD _01248_ sky130_fd_sc_hd__inv_2
X_06922_ net11 VSS VSS VDD VDD _01249_ sky130_fd_sc_hd__inv_1
X_06923_ _01249_ net30 net12 net29 VSS VSS VDD VDD _01250_
+ sky130_fd_sc_hd__nand4_2
X_06924_ net12 net29 VSS VSS VDD VDD _01251_ sky130_fd_sc_hd__nand2_1
X_06925_ net11 _00729_ _01251_ VSS VSS VDD VDD _01252_ sky130_fd_sc_hd__o21ai_2
X_06926_ _01250_ _01252_ VSS VSS VDD VDD _01253_ sky130_fd_sc_hd__nand2_1
X_06927_ net13 net28 VSS VSS VDD VDD _01254_ sky130_fd_sc_hd__nand2_1
X_06928_ _01254_ VSS VSS VDD VDD _01255_ sky130_fd_sc_hd__inv_1
X_06929_ _01253_ _01255_ VSS VSS VDD VDD _01256_ sky130_fd_sc_hd__nand2_1
X_06930_ _01250_ _01252_ _01254_ VSS VSS VDD VDD _01257_ sky130_fd_sc_hd__nand3_1
X_06931_ _01256_ _01257_ VSS VSS VDD VDD _01258_ sky130_fd_sc_hd__nand2_1
X_06932_ _01248_ _01258_ VSS VSS VDD VDD _01259_ sky130_fd_sc_hd__nand2_1
X_06933_ _01253_ _01254_ VSS VSS VDD VDD _01260_ sky130_fd_sc_hd__nand2_1
X_06934_ _01250_ _01252_ _01255_ VSS VSS VDD VDD _01261_ sky130_fd_sc_hd__nand3_1
X_06935_ _01260_ _01261_ VSS VSS VDD VDD _01262_ sky130_fd_sc_hd__nand2_1
X_06936_ _01262_ _01247_ VSS VSS VDD VDD _01263_ sky130_fd_sc_hd__nand2_1
X_06937_ _01217_ VSS VSS VDD VDD _01264_ sky130_fd_sc_hd__inv_1
X_06938_ _01264_ net27 VSS VSS VDD VDD _01265_ sky130_fd_sc_hd__nand2_1
X_06939_ _01217_ _01216_ VSS VSS VDD VDD _01266_ sky130_fd_sc_hd__nand2_1
X_06940_ _01265_ _01266_ VSS VSS VDD VDD _01267_ sky130_fd_sc_hd__nand2_1
X_06941_ _01267_ _01055_ VSS VSS VDD VDD _01268_ sky130_fd_sc_hd__nand2_1
X_06942_ _01265_ _01057_ _01266_ VSS VSS VDD VDD _01269_ sky130_fd_sc_hd__nand3_2
X_06943_ _01268_ _01269_ VSS VSS VDD VDD _01270_ sky130_fd_sc_hd__nand2_2
X_06944_ _01270_ VSS VSS VDD VDD _01271_ sky130_fd_sc_hd__inv_2
X_06945_ _01259_ _01263_ _01271_ VSS VSS VDD VDD _01272_ sky130_fd_sc_hd__nand3_1
X_06946_ _01248_ _01262_ VSS VSS VDD VDD _01273_ sky130_fd_sc_hd__nand2_1
X_06947_ _01258_ _01247_ VSS VSS VDD VDD _01274_ sky130_fd_sc_hd__nand2_1
X_06948_ _01273_ _01274_ _01270_ VSS VSS VDD VDD _01275_ sky130_fd_sc_hd__nand3_1
X_06949_ _01272_ _01275_ VSS VSS VDD VDD _01276_ sky130_fd_sc_hd__nand2_1
X_06950_ _01246_ _01276_ VSS VSS VDD VDD _01277_ sky130_fd_sc_hd__nand2_1
X_06951_ _01273_ _01274_ _01271_ VSS VSS VDD VDD _01278_ sky130_fd_sc_hd__nand3_1
X_06952_ _01259_ _01263_ _01270_ VSS VSS VDD VDD _01279_ sky130_fd_sc_hd__nand3_1
X_06953_ _01278_ _01279_ VSS VSS VDD VDD _01280_ sky130_fd_sc_hd__nand2_1
X_06954_ _01280_ _01245_ VSS VSS VDD VDD _01281_ sky130_fd_sc_hd__nand2_1
X_06955_ _01217_ _01218_ VSS VSS VDD VDD _01282_ sky130_fd_sc_hd__nor2_1
X_06956_ _01219_ _01057_ _01282_ VSS VSS VDD VDD _01283_ sky130_fd_sc_hd__a21oi_1
X_06957_ _01096_ _01283_ VSS VSS VDD VDD _01284_ sky130_fd_sc_hd__nor2_1
X_06958_ _01284_ VSS VSS VDD VDD _01285_ sky130_fd_sc_hd__inv_1
X_06959_ _01283_ _01096_ VSS VSS VDD VDD _01286_ sky130_fd_sc_hd__nand2_1
X_06960_ _01285_ _01286_ VSS VSS VDD VDD _01287_ sky130_fd_sc_hd__nand2_1
X_06961_ _01287_ VSS VSS VDD VDD _01288_ sky130_fd_sc_hd__inv_2
X_06962_ _01277_ _01281_ _01288_ VSS VSS VDD VDD _01289_ sky130_fd_sc_hd__nand3_1
X_06963_ _01246_ _01280_ VSS VSS VDD VDD _01290_ sky130_fd_sc_hd__nand2_2
X_06964_ _01276_ _01245_ VSS VSS VDD VDD _01291_ sky130_fd_sc_hd__nand2_2
X_06965_ _01290_ _01291_ _01287_ VSS VSS VDD VDD _01292_ sky130_fd_sc_hd__nand3_1
X_06966_ _01289_ _01292_ VSS VSS VDD VDD _01293_ sky130_fd_sc_hd__nand2_1
X_06967_ _01244_ _01293_ VSS VSS VDD VDD _01294_ sky130_fd_sc_hd__nand2_1
X_06968_ _01290_ _01291_ _01288_ VSS VSS VDD VDD _01295_ sky130_fd_sc_hd__nand3_1
X_06969_ _01277_ _01281_ _01287_ VSS VSS VDD VDD _01296_ sky130_fd_sc_hd__nand3_1
X_06970_ _01295_ _01296_ VSS VSS VDD VDD _01297_ sky130_fd_sc_hd__nand2_1
X_06971_ _01297_ _01243_ VSS VSS VDD VDD _01298_ sky130_fd_sc_hd__nand2_1
X_06972_ _01294_ _01298_ _01237_ VSS VSS VDD VDD _01299_ sky130_fd_sc_hd__nand3_1
X_06973_ _01244_ _01297_ VSS VSS VDD VDD _01300_ sky130_fd_sc_hd__nand2_1
X_06974_ _01293_ _01243_ VSS VSS VDD VDD _01301_ sky130_fd_sc_hd__nand2_1
X_06975_ _01300_ _01301_ _01238_ VSS VSS VDD VDD _01302_ sky130_fd_sc_hd__nand3_1
X_06976_ _01299_ _01302_ VSS VSS VDD VDD _01303_ sky130_fd_sc_hd__nand2_1
X_06977_ _01232_ _01228_ VSS VSS VDD VDD _01304_ sky130_fd_sc_hd__nand2_1
X_06978_ _01227_ _01233_ VSS VSS VDD VDD _01305_ sky130_fd_sc_hd__nand2_1
X_06979_ _01304_ _01305_ _01240_ VSS VSS VDD VDD _01306_ sky130_fd_sc_hd__nand3_1
X_06980_ _01242_ _01306_ VSS VSS VDD VDD _01307_ sky130_fd_sc_hd__nand2_1
X_06981_ _01103_ _01105_ _01106_ VSS VSS VDD VDD _01308_ sky130_fd_sc_hd__a21boi_1
X_06982_ _01307_ _01308_ VSS VSS VDD VDD _01309_ sky130_fd_sc_hd__nand2_1
X_06983_ _01304_ _01305_ _01241_ VSS VSS VDD VDD _01310_ sky130_fd_sc_hd__nand3_1
X_06984_ _01229_ _01234_ _01240_ VSS VSS VDD VDD _01311_ sky130_fd_sc_hd__nand3_1
X_06985_ _01310_ _01311_ VSS VSS VDD VDD _01312_ sky130_fd_sc_hd__nand2_1
X_06986_ _01138_ _01106_ VSS VSS VDD VDD _01313_ sky130_fd_sc_hd__nand2_1
X_06987_ _01312_ _01313_ VSS VSS VDD VDD _01314_ sky130_fd_sc_hd__nand2_1
X_06988_ _01099_ _01309_ _01314_ VSS VSS VDD VDD _01315_ sky130_fd_sc_hd__a21boi_1
X_06989_ _01303_ _01315_ VSS VSS VDD VDD _01316_ sky130_fd_sc_hd__nand2_1
X_06990_ _01300_ _01301_ _01237_ VSS VSS VDD VDD _01317_ sky130_fd_sc_hd__nand3_1
X_06991_ _01294_ _01298_ _01238_ VSS VSS VDD VDD _01318_ sky130_fd_sc_hd__nand3_1
X_06992_ _01317_ _01318_ VSS VSS VDD VDD _01319_ sky130_fd_sc_hd__nand2_1
X_06993_ _01309_ _01314_ _01099_ VSS VSS VDD VDD _01320_ sky130_fd_sc_hd__nand3_1
X_06994_ _01320_ _01314_ VSS VSS VDD VDD _01321_ sky130_fd_sc_hd__nand2_1
X_06995_ _01319_ _01321_ VSS VSS VDD VDD _01322_ sky130_fd_sc_hd__nand2_1
X_06996_ _01316_ _01322_ VSS VSS VDD VDD _01323_ sky130_fd_sc_hd__nand2_1
X_06997_ _01312_ _01308_ VSS VSS VDD VDD _01324_ sky130_fd_sc_hd__nand2_1
X_06998_ _01307_ _01313_ VSS VSS VDD VDD _01325_ sky130_fd_sc_hd__nand2_1
X_06999_ _01324_ _01325_ _01099_ VSS VSS VDD VDD _01326_ sky130_fd_sc_hd__nand3_1
X_07000_ _01309_ _01314_ _01100_ VSS VSS VDD VDD _01327_ sky130_fd_sc_hd__nand3_1
X_07001_ _01326_ _01327_ VSS VSS VDD VDD _01328_ sky130_fd_sc_hd__nand2_1
X_07002_ _01145_ _01147_ _01148_ VSS VSS VDD VDD _01329_ sky130_fd_sc_hd__a21boi_1
X_07003_ _01328_ _01329_ VSS VSS VDD VDD _01330_ sky130_fd_sc_hd__nand2_1
X_07004_ _01324_ _01325_ _01100_ VSS VSS VDD VDD _01331_ sky130_fd_sc_hd__nand3_1
X_07005_ _01320_ _01331_ VSS VSS VDD VDD _01332_ sky130_fd_sc_hd__nand2_1
X_07006_ _01167_ _01148_ VSS VSS VDD VDD _01333_ sky130_fd_sc_hd__nand2_1
X_07007_ _01332_ _01333_ VSS VSS VDD VDD _01334_ sky130_fd_sc_hd__nand2_1
X_07008_ _01330_ _01334_ VSS VSS VDD VDD _01335_ sky130_fd_sc_hd__nand2_2
X_07009_ _01323_ _01335_ VSS VSS VDD VDD _01336_ sky130_fd_sc_hd__nand2_1
X_07010_ net12 VSS VSS VDD VDD _01337_ sky130_fd_sc_hd__inv_1
X_07011_ _01337_ net30 net13 net29 VSS VSS VDD VDD _01338_
+ sky130_fd_sc_hd__nand4_1
X_07012_ net13 net29 VSS VSS VDD VDD _01339_ sky130_fd_sc_hd__nand2_1
X_07013_ net12 _00729_ _01339_ VSS VSS VDD VDD _01340_ sky130_fd_sc_hd__o21ai_2
X_07014_ _01338_ _01340_ VSS VSS VDD VDD _01341_ sky130_fd_sc_hd__nand2_1
X_07015_ net14 net28 VSS VSS VDD VDD _01342_ sky130_fd_sc_hd__nand2_1
X_07016_ _01341_ _01342_ VSS VSS VDD VDD _01343_ sky130_fd_sc_hd__nand2_1
X_07017_ _01342_ VSS VSS VDD VDD _01344_ sky130_fd_sc_hd__inv_1
X_07018_ _01338_ _01340_ _01344_ VSS VSS VDD VDD _01345_ sky130_fd_sc_hd__nand3_1
X_07019_ _01343_ _01345_ VSS VSS VDD VDD _01346_ sky130_fd_sc_hd__nand2_1
X_07020_ _01255_ _01252_ _01250_ VSS VSS VDD VDD _01347_ sky130_fd_sc_hd__a21boi_0
X_07021_ _01346_ _01347_ VSS VSS VDD VDD _01348_ sky130_fd_sc_hd__nand2_1
X_07022_ _01341_ _01344_ VSS VSS VDD VDD _01349_ sky130_fd_sc_hd__nand2_1
X_07023_ _01338_ _01340_ _01342_ VSS VSS VDD VDD _01350_ sky130_fd_sc_hd__nand3_1
X_07024_ _01349_ _01350_ VSS VSS VDD VDD _01351_ sky130_fd_sc_hd__nand2_1
X_07025_ _01261_ _01250_ VSS VSS VDD VDD _01352_ sky130_fd_sc_hd__nand2_1
X_07026_ _01351_ _01352_ VSS VSS VDD VDD _01353_ sky130_fd_sc_hd__nand2_1
X_07027_ _01348_ _01353_ _01271_ VSS VSS VDD VDD _01354_ sky130_fd_sc_hd__nand3_1
X_07028_ _01351_ _01347_ VSS VSS VDD VDD _01355_ sky130_fd_sc_hd__nand2_1
X_07029_ _01346_ _01352_ VSS VSS VDD VDD _01356_ sky130_fd_sc_hd__nand2_1
X_07030_ _01355_ _01356_ _01270_ VSS VSS VDD VDD _01357_ sky130_fd_sc_hd__nand3_1
X_07031_ _01354_ _01357_ VSS VSS VDD VDD _01358_ sky130_fd_sc_hd__nand2_1
X_07032_ _01271_ _01273_ _01274_ VSS VSS VDD VDD _01359_ sky130_fd_sc_hd__a21boi_1
X_07033_ _01358_ _01359_ VSS VSS VDD VDD _01360_ sky130_fd_sc_hd__nand2_1
X_07034_ _01355_ _01356_ _01271_ VSS VSS VDD VDD _01361_ sky130_fd_sc_hd__nand3_1
X_07035_ _01348_ _01353_ _01270_ VSS VSS VDD VDD _01362_ sky130_fd_sc_hd__nand3_1
X_07036_ _01361_ _01362_ VSS VSS VDD VDD _01363_ sky130_fd_sc_hd__nand2_1
X_07037_ _01278_ _01274_ VSS VSS VDD VDD _01364_ sky130_fd_sc_hd__nand2_1
X_07038_ _01363_ _01364_ VSS VSS VDD VDD _01365_ sky130_fd_sc_hd__nand2_1
X_07039_ _01269_ _01265_ VSS VSS VDD VDD _01366_ sky130_fd_sc_hd__nand2_1
X_07040_ _01095_ _01366_ VSS VSS VDD VDD _01367_ sky130_fd_sc_hd__nor2_1
X_07041_ _01366_ _01095_ VSS VSS VDD VDD _01368_ sky130_fd_sc_hd__nand2_2
X_07042_ _01368_ VSS VSS VDD VDD _01369_ sky130_fd_sc_hd__inv_2
X_07043_ _01367_ _01369_ VSS VSS VDD VDD _01370_ sky130_fd_sc_hd__nor2_2
X_07044_ _01360_ _01365_ _01370_ VSS VSS VDD VDD _01371_ sky130_fd_sc_hd__nand3_1
X_07045_ _01363_ _01359_ VSS VSS VDD VDD _01372_ sky130_fd_sc_hd__nand2_1
X_07046_ _01358_ _01364_ VSS VSS VDD VDD _01373_ sky130_fd_sc_hd__nand2_1
X_07047_ _01370_ VSS VSS VDD VDD _01374_ sky130_fd_sc_hd__inv_2
X_07048_ _01372_ _01373_ _01374_ VSS VSS VDD VDD _01375_ sky130_fd_sc_hd__nand3_1
X_07049_ _01371_ _01375_ VSS VSS VDD VDD _01376_ sky130_fd_sc_hd__nand2_1
X_07050_ _01290_ _01288_ _01291_ VSS VSS VDD VDD _01377_ sky130_fd_sc_hd__a21boi_1
X_07051_ _01376_ _01377_ VSS VSS VDD VDD _01378_ sky130_fd_sc_hd__nand2_1
X_07052_ _01372_ _01373_ _01370_ VSS VSS VDD VDD _01379_ sky130_fd_sc_hd__nand3_1
X_07053_ _01360_ _01365_ _01374_ VSS VSS VDD VDD _01380_ sky130_fd_sc_hd__nand3_1
X_07054_ _01379_ _01380_ VSS VSS VDD VDD _01381_ sky130_fd_sc_hd__nand2_1
X_07055_ _01295_ _01291_ VSS VSS VDD VDD _01382_ sky130_fd_sc_hd__nand2_1
X_07056_ _01381_ _01382_ VSS VSS VDD VDD _01383_ sky130_fd_sc_hd__nand2_1
X_07057_ _01378_ _01383_ _01284_ VSS VSS VDD VDD _01384_ sky130_fd_sc_hd__nand3_1
X_07058_ _01384_ _01383_ VSS VSS VDD VDD _01385_ sky130_fd_sc_hd__nand2_1
X_07059_ _01385_ VSS VSS VDD VDD _01386_ sky130_fd_sc_hd__inv_1
X_07060_ _01371_ _01365_ VSS VSS VDD VDD _01387_ sky130_fd_sc_hd__nand2_1
X_07061_ _01387_ VSS VSS VDD VDD _01388_ sky130_fd_sc_hd__inv_2
X_07062_ _01354_ _01353_ VSS VSS VDD VDD _01389_ sky130_fd_sc_hd__nand2_1
X_07063_ _01389_ VSS VSS VDD VDD _01390_ sky130_fd_sc_hd__inv_2
X_07064_ net13 _00729_ VSS VSS VDD VDD _01391_ sky130_fd_sc_hd__nor2_1
X_07065_ _01391_ net14 net29 VSS VSS VDD VDD _01392_ sky130_fd_sc_hd__nand3_1
X_07066_ _01391_ VSS VSS VDD VDD _01393_ sky130_fd_sc_hd__inv_1
X_07067_ net14 net29 VSS VSS VDD VDD _01394_ sky130_fd_sc_hd__nand2_1
X_07068_ _01393_ _01394_ VSS VSS VDD VDD _01395_ sky130_fd_sc_hd__nand2_1
X_07069_ _01392_ _01395_ VSS VSS VDD VDD _01396_ sky130_fd_sc_hd__nand2_1
X_07070_ _01396_ _01342_ VSS VSS VDD VDD _01397_ sky130_fd_sc_hd__nand2_1
X_07071_ _01392_ _01395_ _01344_ VSS VSS VDD VDD _01398_ sky130_fd_sc_hd__nand3_1
X_07072_ _01397_ _01398_ VSS VSS VDD VDD _01399_ sky130_fd_sc_hd__nand2_1
X_07073_ _01345_ _01338_ VSS VSS VDD VDD _01400_ sky130_fd_sc_hd__nand2_1
X_07074_ _01400_ VSS VSS VDD VDD _01401_ sky130_fd_sc_hd__inv_2
X_07075_ _01399_ _01401_ VSS VSS VDD VDD _01402_ sky130_fd_sc_hd__nand2_1
X_07076_ _01396_ _01344_ VSS VSS VDD VDD _01403_ sky130_fd_sc_hd__nand2_1
X_07077_ _01392_ _01395_ _01342_ VSS VSS VDD VDD _01404_ sky130_fd_sc_hd__nand3_1
X_07078_ _01403_ _01404_ VSS VSS VDD VDD _01405_ sky130_fd_sc_hd__nand2_1
X_07079_ _01405_ _01400_ VSS VSS VDD VDD _01406_ sky130_fd_sc_hd__nand2_1
X_07080_ _01402_ _01406_ _01271_ VSS VSS VDD VDD _01407_ sky130_fd_sc_hd__nand3_1
X_07081_ _01405_ _01401_ VSS VSS VDD VDD _01408_ sky130_fd_sc_hd__nand2_1
X_07082_ _01399_ _01400_ VSS VSS VDD VDD _01409_ sky130_fd_sc_hd__nand2_1
X_07083_ _01408_ _01409_ _01270_ VSS VSS VDD VDD _01410_ sky130_fd_sc_hd__nand3_1
X_07084_ _01407_ _01410_ VSS VSS VDD VDD _01411_ sky130_fd_sc_hd__nand2_1
X_07085_ _01390_ _01411_ VSS VSS VDD VDD _01412_ sky130_fd_sc_hd__nand2_1
X_07086_ _01408_ _01409_ _01271_ VSS VSS VDD VDD _01413_ sky130_fd_sc_hd__nand3_1
X_07087_ _01402_ _01406_ _01270_ VSS VSS VDD VDD _01414_ sky130_fd_sc_hd__nand3_1
X_07088_ _01413_ _01414_ VSS VSS VDD VDD _01415_ sky130_fd_sc_hd__nand2_1
X_07089_ _01415_ _01389_ VSS VSS VDD VDD _01416_ sky130_fd_sc_hd__nand2_1
X_07090_ _01412_ _01416_ _01370_ VSS VSS VDD VDD _01417_ sky130_fd_sc_hd__nand3_1
X_07091_ _01390_ _01415_ VSS VSS VDD VDD _01418_ sky130_fd_sc_hd__nand2_1
X_07092_ _01411_ _01389_ VSS VSS VDD VDD _01419_ sky130_fd_sc_hd__nand2_1
X_07093_ _01418_ _01419_ _01374_ VSS VSS VDD VDD _01420_ sky130_fd_sc_hd__nand3_1
X_07094_ _01417_ _01420_ VSS VSS VDD VDD _01421_ sky130_fd_sc_hd__nand2_1
X_07095_ _01388_ _01421_ VSS VSS VDD VDD _01422_ sky130_fd_sc_hd__nand2_1
X_07096_ _01418_ _01419_ _01370_ VSS VSS VDD VDD _01423_ sky130_fd_sc_hd__nand3_1
X_07097_ _01412_ _01416_ _01374_ VSS VSS VDD VDD _01424_ sky130_fd_sc_hd__nand3_1
X_07098_ _01423_ _01424_ VSS VSS VDD VDD _01425_ sky130_fd_sc_hd__nand2_1
X_07099_ _01425_ _01387_ VSS VSS VDD VDD _01426_ sky130_fd_sc_hd__nand2_1
X_07100_ _01422_ _01426_ _01369_ VSS VSS VDD VDD _01427_ sky130_fd_sc_hd__nand3_1
X_07101_ _01388_ _01425_ VSS VSS VDD VDD _01428_ sky130_fd_sc_hd__nand2_1
X_07102_ _01421_ _01387_ VSS VSS VDD VDD _01429_ sky130_fd_sc_hd__nand2_1
X_07103_ _01428_ _01429_ _01368_ VSS VSS VDD VDD _01430_ sky130_fd_sc_hd__nand3_1
X_07104_ _01427_ _01430_ VSS VSS VDD VDD _01431_ sky130_fd_sc_hd__nand2_1
X_07105_ _01386_ _01431_ VSS VSS VDD VDD _01432_ sky130_fd_sc_hd__nand2_1
X_07106_ _01428_ _01429_ _01369_ VSS VSS VDD VDD _01433_ sky130_fd_sc_hd__nand3_1
X_07107_ _01422_ _01426_ _01368_ VSS VSS VDD VDD _01434_ sky130_fd_sc_hd__nand3_1
X_07108_ _01433_ _01434_ VSS VSS VDD VDD _01435_ sky130_fd_sc_hd__nand2_1
X_07109_ _01435_ _01385_ VSS VSS VDD VDD _01436_ sky130_fd_sc_hd__nand2_1
X_07110_ _01432_ _01436_ VSS VSS VDD VDD _01437_ sky130_fd_sc_hd__nand2_2
X_07111_ _01437_ VSS VSS VDD VDD _01438_ sky130_fd_sc_hd__inv_1
X_07112_ _01381_ _01377_ VSS VSS VDD VDD _01439_ sky130_fd_sc_hd__nand2_1
X_07113_ _01376_ _01382_ VSS VSS VDD VDD _01440_ sky130_fd_sc_hd__nand2_1
X_07114_ _01439_ _01440_ _01284_ VSS VSS VDD VDD _01441_ sky130_fd_sc_hd__nand3_1
X_07115_ _01378_ _01383_ _01285_ VSS VSS VDD VDD _01442_ sky130_fd_sc_hd__nand3_1
X_07116_ _01441_ _01442_ VSS VSS VDD VDD _01443_ sky130_fd_sc_hd__nand2_1
X_07117_ _01300_ _01237_ _01301_ VSS VSS VDD VDD _01444_ sky130_fd_sc_hd__a21boi_0
X_07118_ _01443_ _01444_ VSS VSS VDD VDD _01445_ sky130_fd_sc_hd__nand2_1
X_07119_ _01439_ _01440_ _01285_ VSS VSS VDD VDD _01446_ sky130_fd_sc_hd__nand3_1
X_07120_ _01384_ _01446_ VSS VSS VDD VDD _01447_ sky130_fd_sc_hd__nand2_1
X_07121_ _01317_ _01301_ VSS VSS VDD VDD _01448_ sky130_fd_sc_hd__nand2_1
X_07122_ _01447_ _01448_ VSS VSS VDD VDD _01449_ sky130_fd_sc_hd__nand2_1
X_07123_ _01445_ _01449_ VSS VSS VDD VDD _01450_ sky130_fd_sc_hd__nand2_2
X_07124_ _01438_ _01450_ VSS VSS VDD VDD _01451_ sky130_fd_sc_hd__nand2_1
X_07125_ _01336_ _01451_ VSS VSS VDD VDD _01452_ sky130_fd_sc_hd__nor2_1
X_07126_ _01195_ _01452_ VSS VSS VDD VDD _01453_ sky130_fd_sc_hd__nand2_1
X_07127_ _01443_ _01448_ VSS VSS VDD VDD _01454_ sky130_fd_sc_hd__nand2_1
X_07128_ _01454_ _01437_ _01436_ VSS VSS VDD VDD _01455_ sky130_fd_sc_hd__o21ai_0
X_07129_ _01303_ _01321_ VSS VSS VDD VDD _01456_ sky130_fd_sc_hd__nand2_1
X_07130_ _01328_ _01333_ VSS VSS VDD VDD _01457_ sky130_fd_sc_hd__nand2_1
X_07131_ _01456_ _01457_ VSS VSS VDD VDD _01458_ sky130_fd_sc_hd__nand2_1
X_07132_ _01319_ _01315_ VSS VSS VDD VDD _01459_ sky130_fd_sc_hd__nand2_1
X_07133_ _01458_ _01459_ VSS VSS VDD VDD _01460_ sky130_fd_sc_hd__nand2_1
X_07134_ _01460_ _01451_ VSS VSS VDD VDD _01461_ sky130_fd_sc_hd__nor2_1
X_07135_ _01455_ _01461_ VSS VSS VDD VDD _01462_ sky130_fd_sc_hd__nor2_1
X_07136_ _01453_ _01462_ VSS VSS VDD VDD _01463_ sky130_fd_sc_hd__nand2_1
X_07137_ _01394_ _01393_ VSS VSS VDD VDD _01464_ sky130_fd_sc_hd__nor2_1
X_07138_ _01395_ _01344_ _01464_ VSS VSS VDD VDD _01465_ sky130_fd_sc_hd__a21oi_1
X_07139_ net14 _00729_ _01342_ _01394_ VSS VSS VDD VDD _01466_
+ sky130_fd_sc_hd__o211ai_1
X_07140_ _01344_ net29 VSS VSS VDD VDD _01467_ sky130_fd_sc_hd__nand2_1
X_07141_ _01465_ _01466_ _01467_ VSS VSS VDD VDD _01468_ sky130_fd_sc_hd__nand3_1
X_07142_ _01468_ _01467_ VSS VSS VDD VDD _01469_ sky130_fd_sc_hd__nand2_1
X_07143_ _01469_ _01271_ VSS VSS VDD VDD _01470_ sky130_fd_sc_hd__nand2_1
X_07144_ _01468_ _01270_ _01467_ VSS VSS VDD VDD _01471_ sky130_fd_sc_hd__nand3_1
X_07145_ _01470_ _01471_ VSS VSS VDD VDD _01472_ sky130_fd_sc_hd__nand2_1
X_07146_ _01271_ _01402_ _01406_ VSS VSS VDD VDD _01473_ sky130_fd_sc_hd__a21boi_1
X_07147_ _01472_ _01473_ VSS VSS VDD VDD _01474_ sky130_fd_sc_hd__nand2_1
X_07148_ _01469_ _01270_ VSS VSS VDD VDD _01475_ sky130_fd_sc_hd__nand2_1
X_07149_ _01468_ _01271_ _01467_ VSS VSS VDD VDD _01476_ sky130_fd_sc_hd__nand3_1
X_07150_ _01475_ _01476_ VSS VSS VDD VDD _01477_ sky130_fd_sc_hd__nand2_1
X_07151_ _01407_ _01406_ VSS VSS VDD VDD _01478_ sky130_fd_sc_hd__nand2_1
X_07152_ _01477_ _01478_ VSS VSS VDD VDD _01479_ sky130_fd_sc_hd__nand2_1
X_07153_ _01474_ _01479_ VSS VSS VDD VDD _01480_ sky130_fd_sc_hd__nand2_1
X_07154_ _01480_ _01374_ VSS VSS VDD VDD _01481_ sky130_fd_sc_hd__nand2_1
X_07155_ _01474_ _01479_ _01370_ VSS VSS VDD VDD _01482_ sky130_fd_sc_hd__nand3_1
X_07156_ _01481_ _01482_ VSS VSS VDD VDD _01483_ sky130_fd_sc_hd__nand2_1
X_07157_ _01370_ _01412_ _01416_ VSS VSS VDD VDD _01484_ sky130_fd_sc_hd__a21boi_1
X_07158_ _01483_ _01484_ VSS VSS VDD VDD _01485_ sky130_fd_sc_hd__nand2_1
X_07159_ _01480_ _01370_ VSS VSS VDD VDD _01486_ sky130_fd_sc_hd__nand2_1
X_07160_ _01474_ _01479_ _01374_ VSS VSS VDD VDD _01487_ sky130_fd_sc_hd__nand3_1
X_07161_ _01486_ _01487_ VSS VSS VDD VDD _01488_ sky130_fd_sc_hd__nand2_1
X_07162_ _01417_ _01416_ VSS VSS VDD VDD _01489_ sky130_fd_sc_hd__nand2_1
X_07163_ _01488_ _01489_ VSS VSS VDD VDD _01490_ sky130_fd_sc_hd__nand2_1
X_07164_ _01485_ _01490_ _01369_ VSS VSS VDD VDD _01491_ sky130_fd_sc_hd__nand3_1
X_07165_ _01488_ _01484_ VSS VSS VDD VDD _01492_ sky130_fd_sc_hd__nand2_1
X_07166_ _01483_ _01489_ VSS VSS VDD VDD _01493_ sky130_fd_sc_hd__nand2_1
X_07167_ _01492_ _01493_ _01368_ VSS VSS VDD VDD _01494_ sky130_fd_sc_hd__nand3_1
X_07168_ _01491_ _01494_ VSS VSS VDD VDD _01495_ sky130_fd_sc_hd__nand2_1
X_07169_ _01369_ _01422_ _01426_ VSS VSS VDD VDD _01496_ sky130_fd_sc_hd__a21boi_1
X_07170_ _01495_ _01496_ VSS VSS VDD VDD _01497_ sky130_fd_sc_hd__nand2_1
X_07171_ _01492_ _01493_ _01369_ VSS VSS VDD VDD _01498_ sky130_fd_sc_hd__nand3_1
X_07172_ _01485_ _01490_ _01368_ VSS VSS VDD VDD _01499_ sky130_fd_sc_hd__nand3_1
X_07173_ _01498_ _01499_ VSS VSS VDD VDD _01500_ sky130_fd_sc_hd__nand2_1
X_07174_ _01427_ _01426_ VSS VSS VDD VDD _01501_ sky130_fd_sc_hd__nand2_1
X_07175_ _01500_ _01501_ VSS VSS VDD VDD _01502_ sky130_fd_sc_hd__nand2_1
X_07176_ _01497_ _01502_ VSS VSS VDD VDD _01503_ sky130_fd_sc_hd__nand2_2
X_07177_ _01463_ _01503_ VSS VSS VDD VDD _01504_ sky130_fd_sc_hd__nand2_2
X_07178_ _01503_ VSS VSS VDD VDD _01505_ sky130_fd_sc_hd__inv_1
X_07179_ _01453_ _01462_ _01505_ VSS VSS VDD VDD _01506_ sky130_fd_sc_hd__nand3_1
X_07180_ _01504_ _01506_ VSS VSS VDD VDD _01507_ sky130_fd_sc_hd__nand2_1
X_07181_ _01507_ net42 VSS VSS VDD VDD _01508_ sky130_fd_sc_hd__nand2_2
X_07182_ _01190_ VSS VSS VDD VDD _01509_ sky130_fd_sc_hd__inv_1
X_07183_ _01335_ _01509_ VSS VSS VDD VDD _01510_ sky130_fd_sc_hd__nand2_1
X_07184_ _01510_ _01457_ VSS VSS VDD VDD _01511_ sky130_fd_sc_hd__nand2_1
X_07185_ _01191_ _01016_ VSS VSS VDD VDD _01512_ sky130_fd_sc_hd__nand2_1
X_07186_ _01178_ _01184_ VSS VSS VDD VDD _01513_ sky130_fd_sc_hd__nand2_1
X_07187_ _01512_ _01513_ VSS VSS VDD VDD _01514_ sky130_fd_sc_hd__nand2_1
X_07188_ _01335_ _01173_ VSS VSS VDD VDD _01515_ sky130_fd_sc_hd__nand2_1
X_07189_ _01514_ _01515_ VSS VSS VDD VDD _01516_ sky130_fd_sc_hd__nor2_1
X_07190_ _01511_ _01516_ VSS VSS VDD VDD _01517_ sky130_fd_sc_hd__nor2_2
X_07191_ _01186_ _00927_ VSS VSS VDD VDD _01518_ sky130_fd_sc_hd__nand2_1
X_07192_ _01518_ _01515_ VSS VSS VDD VDD _01519_ sky130_fd_sc_hd__nor2_1
X_07193_ _00990_ VSS VSS VDD VDD _01520_ sky130_fd_sc_hd__inv_1
X_07194_ _00975_ _01520_ VSS VSS VDD VDD _01521_ sky130_fd_sc_hd__nand2_1
X_07195_ _00970_ _00974_ _00990_ VSS VSS VDD VDD _01522_ sky130_fd_sc_hd__nand3_1
X_07196_ _01521_ _01522_ VSS VSS VDD VDD _01523_ sky130_fd_sc_hd__nand2_1
X_07197_ _00969_ _01009_ _01523_ VSS VSS VDD VDD _01524_ sky130_fd_sc_hd__nand3_1
X_07198_ _00931_ _00965_ VSS VSS VDD VDD _01525_ sky130_fd_sc_hd__nand2_1
X_07199_ _01525_ _01010_ _01015_ VSS VSS VDD VDD _01526_ sky130_fd_sc_hd__a21oi_1
X_07200_ _01524_ _01526_ VSS VSS VDD VDD _01527_ sky130_fd_sc_hd__nand2_1
X_07201_ _01519_ _01527_ VSS VSS VDD VDD _01528_ sky130_fd_sc_hd__nand2_1
X_07202_ _01517_ _01528_ VSS VSS VDD VDD _01529_ sky130_fd_sc_hd__nand2_2
X_07203_ _01450_ _01323_ VSS VSS VDD VDD _01530_ sky130_fd_sc_hd__nand2_1
X_07204_ _01437_ _01503_ _01530_ VSS VSS VDD VDD _01531_ sky130_fd_sc_hd__nor3_2
X_07205_ _01529_ _01531_ VSS VSS VDD VDD _01532_ sky130_fd_sc_hd__nand2_4
X_07206_ _01437_ _01503_ VSS VSS VDD VDD _01533_ sky130_fd_sc_hd__nor2_1
X_07207_ _01448_ _01443_ VSS VSS VDD VDD _01534_ sky130_fd_sc_hd__nor2_1
X_07208_ _01456_ _01534_ _01454_ VSS VSS VDD VDD _01535_ sky130_fd_sc_hd__o21ai_1
X_07209_ _01497_ _01385_ _01435_ VSS VSS VDD VDD _01536_ sky130_fd_sc_hd__nand3_1
X_07210_ _01536_ _01502_ VSS VSS VDD VDD _01537_ sky130_fd_sc_hd__nand2_1
X_07211_ _01533_ _01535_ _01537_ VSS VSS VDD VDD _01538_ sky130_fd_sc_hd__a21oi_4
X_07212_ _01472_ _01473_ _01370_ VSS VSS VDD VDD _01539_ sky130_fd_sc_hd__nand3_1
X_07213_ _01370_ _01479_ _01539_ VSS VSS VDD VDD _01540_ sky130_fd_sc_hd__o21ai_0
X_07214_ _01471_ _01540_ VSS VSS VDD VDD _01541_ sky130_fd_sc_hd__xor2_1
X_07215_ _01485_ _01369_ VSS VSS VDD VDD _01542_ sky130_fd_sc_hd__nand2_1
X_07216_ _01490_ _01368_ VSS VSS VDD VDD _01543_ sky130_fd_sc_hd__nand2_1
X_07217_ _01542_ _01543_ VSS VSS VDD VDD _01544_ sky130_fd_sc_hd__nand2_1
X_07218_ _01541_ _01544_ VSS VSS VDD VDD _01545_ sky130_fd_sc_hd__xor2_1
X_07219_ _01545_ VSS VSS VDD VDD _01546_ sky130_fd_sc_hd__clkinv_1
X_07220_ _01532_ net43 _01538_ _01546_ VSS VSS VDD VDD _01547_
+ sky130_fd_sc_hd__nand4_1
X_07221_ _01532_ _01538_ _01546_ VSS VSS VDD VDD _01548_ sky130_fd_sc_hd__nand3_2
X_07222_ net43 VSS VSS VDD VDD _01549_ sky130_fd_sc_hd__inv_1
X_07223_ _01548_ _01549_ VSS VSS VDD VDD _01550_ sky130_fd_sc_hd__nand2_1
X_07224_ _01508_ _01547_ _01550_ VSS VSS VDD VDD _01551_ sky130_fd_sc_hd__a21boi_0
Xoutput47 net47 VSS VSS VDD VDD c00[19] sky130_fd_sc_hd__clkdlybuf4s50_1
X_07226_ net45 VSS VSS VDD VDD _01553_ sky130_fd_sc_hd__inv_1
X_07227_ _01548_ _01553_ VSS VSS VDD VDD _01554_ sky130_fd_sc_hd__nand2_2
X_07228_ _01532_ net45 _01538_ _01546_ VSS VSS VDD VDD _01555_
+ sky130_fd_sc_hd__nand4_1
X_07229_ _01554_ _01555_ VSS VSS VDD VDD _01556_ sky130_fd_sc_hd__nand2_2
X_07230_ net44 VSS VSS VDD VDD _01557_ sky130_fd_sc_hd__inv_1
X_07231_ _01548_ _01557_ VSS VSS VDD VDD _01558_ sky130_fd_sc_hd__nand2_4
X_07232_ _01532_ net44 _01538_ _01546_ VSS VSS VDD VDD _01559_
+ sky130_fd_sc_hd__nand4_1
X_07233_ _01558_ _01559_ VSS VSS VDD VDD _01560_ sky130_fd_sc_hd__nand2_4
X_07234_ _01556_ _01560_ VSS VSS VDD VDD _01561_ sky130_fd_sc_hd__nor2_1
X_07235_ _01551_ _01561_ VSS VSS VDD VDD _01562_ sky130_fd_sc_hd__nand2_1
X_07236_ _01555_ _01559_ VSS VSS VDD VDD _01563_ sky130_fd_sc_hd__nand2_1
X_07237_ _01563_ VSS VSS VDD VDD _01564_ sky130_fd_sc_hd__inv_1
X_07238_ _01562_ _01564_ VSS VSS VDD VDD _01565_ sky130_fd_sc_hd__nand2_1
X_07239_ net46 VSS VSS VDD VDD _01566_ sky130_fd_sc_hd__inv_1
X_07240_ _01548_ _01566_ VSS VSS VDD VDD _01567_ sky130_fd_sc_hd__nand2_2
X_07241_ _01532_ net46 _01538_ _01546_ VSS VSS VDD VDD _01568_
+ sky130_fd_sc_hd__nand4_1
X_07242_ _01567_ _01568_ VSS VSS VDD VDD _01569_ sky130_fd_sc_hd__nand2_2
X_07243_ _01569_ VSS VSS VDD VDD _01570_ sky130_fd_sc_hd__inv_1
X_07244_ net47 VSS VSS VDD VDD _01571_ sky130_fd_sc_hd__inv_1
X_07245_ _01548_ _01571_ VSS VSS VDD VDD _01572_ sky130_fd_sc_hd__nand2_1
X_07246_ _01532_ net47 _01538_ _01546_ VSS VSS VDD VDD _01573_
+ sky130_fd_sc_hd__nand4_1
X_07247_ _01572_ _01573_ VSS VSS VDD VDD _01574_ sky130_fd_sc_hd__nand2_1
X_07248_ _01574_ VSS VSS VDD VDD _01575_ sky130_fd_sc_hd__inv_2
X_07249_ _01570_ _01575_ VSS VSS VDD VDD _01576_ sky130_fd_sc_hd__nand2_1
X_07250_ net50 VSS VSS VDD VDD _01577_ sky130_fd_sc_hd__inv_1
X_07251_ _01548_ _01577_ VSS VSS VDD VDD _01578_ sky130_fd_sc_hd__nand2_1
X_07252_ _01532_ net50 _01538_ _01546_ VSS VSS VDD VDD _01579_
+ sky130_fd_sc_hd__nand4_1
X_07253_ _01578_ _01579_ VSS VSS VDD VDD _01580_ sky130_fd_sc_hd__nand2_1
X_07254_ _01580_ VSS VSS VDD VDD _01581_ sky130_fd_sc_hd__inv_1
X_07255_ net49 VSS VSS VDD VDD _01582_ sky130_fd_sc_hd__inv_1
X_07256_ _01548_ _01582_ VSS VSS VDD VDD _01583_ sky130_fd_sc_hd__nand2_1
X_07257_ _01532_ net49 _01538_ _01546_ VSS VSS VDD VDD _01584_
+ sky130_fd_sc_hd__nand4_1
X_07258_ _01583_ _01584_ VSS VSS VDD VDD _01585_ sky130_fd_sc_hd__nand2_1
X_07259_ _01585_ VSS VSS VDD VDD _01586_ sky130_fd_sc_hd__inv_1
X_07260_ _01581_ _01586_ VSS VSS VDD VDD _01587_ sky130_fd_sc_hd__nand2_1
X_07261_ _01576_ _01587_ VSS VSS VDD VDD _01588_ sky130_fd_sc_hd__nor2_1
X_07262_ _01548_ VSS VSS VDD VDD _01589_ sky130_fd_sc_hd__inv_1
X_07263_ net46 net47 net49 net50 _01589_ VSS VSS VDD VDD _01590_
+ sky130_fd_sc_hd__o41ai_1
X_07264_ _01565_ _01588_ _01590_ VSS VSS VDD VDD _01591_ sky130_fd_sc_hd__a21boi_1
X_07265_ _01550_ _01547_ VSS VSS VDD VDD _01592_ sky130_fd_sc_hd__nand2_1
X_07266_ net42 _01504_ _01506_ VSS VSS VDD VDD _01593_ sky130_fd_sc_hd__nand3b_1
X_07267_ _01508_ _01593_ VSS VSS VDD VDD _01594_ sky130_fd_sc_hd__nand2_1
X_07268_ _01592_ _01594_ VSS VSS VDD VDD _01595_ sky130_fd_sc_hd__nor2_1
X_07269_ _01595_ _01561_ VSS VSS VDD VDD _01596_ sky130_fd_sc_hd__nand2_1
X_07270_ _01596_ _01588_ VSS VSS VDD VDD _01597_ sky130_fd_sc_hd__nor2b_1
X_07271_ _01460_ _01194_ VSS VSS VDD VDD _01598_ sky130_fd_sc_hd__nand2_1
X_07272_ _01598_ VSS VSS VDD VDD _01599_ sky130_fd_sc_hd__inv_1
X_07273_ _01189_ _01599_ VSS VSS VDD VDD _01600_ sky130_fd_sc_hd__nand2_1
X_07274_ _01336_ _01460_ VSS VSS VDD VDD _01601_ sky130_fd_sc_hd__nand2_1
X_07275_ _01600_ _01450_ _01601_ VSS VSS VDD VDD _01602_ sky130_fd_sc_hd__nand3_1
X_07276_ _01460_ VSS VSS VDD VDD _01603_ sky130_fd_sc_hd__inv_1
X_07277_ _01194_ _01336_ VSS VSS VDD VDD _01604_ sky130_fd_sc_hd__nor2_1
X_07278_ _01603_ _01604_ VSS VSS VDD VDD _01605_ sky130_fd_sc_hd__nor2_1
X_07279_ _01187_ _01336_ VSS VSS VDD VDD _01606_ sky130_fd_sc_hd__nor2_1
X_07280_ _01606_ _01019_ VSS VSS VDD VDD _01607_ sky130_fd_sc_hd__nand2_1
X_07281_ _01450_ VSS VSS VDD VDD _01608_ sky130_fd_sc_hd__inv_1
X_07282_ _01605_ _01607_ _01608_ VSS VSS VDD VDD _01609_ sky130_fd_sc_hd__nand3_1
X_07283_ _01602_ _01609_ net40 VSS VSS VDD VDD _01610_ sky130_fd_sc_hd__nand3_1
X_07284_ _01600_ _01608_ _01601_ VSS VSS VDD VDD _01611_ sky130_fd_sc_hd__nand3_1
X_07285_ _01605_ _01607_ _01450_ VSS VSS VDD VDD _01612_ sky130_fd_sc_hd__nand3_1
X_07286_ net40 VSS VSS VDD VDD _01613_ sky130_fd_sc_hd__inv_1
X_07287_ _01611_ _01612_ _01613_ VSS VSS VDD VDD _01614_ sky130_fd_sc_hd__nand3_1
X_07288_ _01610_ _01614_ VSS VSS VDD VDD _01615_ sky130_fd_sc_hd__nand2_1
X_07289_ _01332_ _01329_ VSS VSS VDD VDD _01616_ sky130_fd_sc_hd__nand2_1
X_07290_ _01509_ _01616_ _01457_ VSS VSS VDD VDD _01617_ sky130_fd_sc_hd__a21boi_0
X_07291_ _01530_ _01617_ VSS VSS VDD VDD _01618_ sky130_fd_sc_hd__nor2_1
X_07292_ _01535_ _01618_ VSS VSS VDD VDD _01619_ sky130_fd_sc_hd__nor2_1
X_07293_ _01515_ _01530_ VSS VSS VDD VDD _01620_ sky130_fd_sc_hd__nor2_1
X_07294_ _00969_ _01523_ VSS VSS VDD VDD _01621_ sky130_fd_sc_hd__nand2_1
X_07295_ _01621_ _01518_ VSS VSS VDD VDD _01622_ sky130_fd_sc_hd__nor2_1
X_07296_ _01620_ _01009_ _01622_ VSS VSS VDD VDD _01623_ sky130_fd_sc_hd__nand3_1
X_07297_ _01526_ _01186_ _00927_ VSS VSS VDD VDD _01624_ sky130_fd_sc_hd__nand3b_1
X_07298_ _01624_ _01514_ VSS VSS VDD VDD _01625_ sky130_fd_sc_hd__nand2_1
X_07299_ _01625_ _01620_ VSS VSS VDD VDD _01626_ sky130_fd_sc_hd__nand2_1
X_07300_ _01619_ _01623_ _01626_ VSS VSS VDD VDD _01627_ sky130_fd_sc_hd__nand3_1
X_07301_ _01627_ _01438_ VSS VSS VDD VDD _01628_ sky130_fd_sc_hd__nand2_1
X_07302_ _01619_ _01623_ _01437_ _01626_ VSS VSS VDD VDD _01629_
+ sky130_fd_sc_hd__nand4_1
X_07303_ _01628_ _01629_ VSS VSS VDD VDD _01630_ sky130_fd_sc_hd__nand2_1
X_07304_ net41 VSS VSS VDD VDD _01631_ sky130_fd_sc_hd__inv_1
X_07305_ _01630_ _01631_ VSS VSS VDD VDD _01632_ sky130_fd_sc_hd__nand2_1
X_07306_ _01628_ _01629_ net41 VSS VSS VDD VDD _01633_ sky130_fd_sc_hd__nand3_1
X_07307_ _01632_ _01633_ VSS VSS VDD VDD _01634_ sky130_fd_sc_hd__nand2_1
X_07308_ _01615_ _01634_ VSS VSS VDD VDD _01635_ sky130_fd_sc_hd__nor2_1
X_07309_ _01529_ _01323_ VSS VSS VDD VDD _01636_ sky130_fd_sc_hd__nand2_1
X_07310_ _01323_ _01517_ _01528_ VSS VSS VDD VDD _01637_ sky130_fd_sc_hd__nand3b_1
X_07311_ _01636_ _01637_ VSS VSS VDD VDD _01638_ sky130_fd_sc_hd__nand2_1
X_07312_ net39 VSS VSS VDD VDD _01639_ sky130_fd_sc_hd__inv_1
X_07313_ _01638_ _01639_ VSS VSS VDD VDD _01640_ sky130_fd_sc_hd__nand2_1
X_07314_ _01527_ _00927_ VSS VSS VDD VDD _01641_ sky130_fd_sc_hd__nand2_1
X_07315_ _01014_ _01016_ VSS VSS VDD VDD _01642_ sky130_fd_sc_hd__nand2_1
X_07316_ _01642_ _01524_ _01526_ VSS VSS VDD VDD _01643_ sky130_fd_sc_hd__nand3_1
X_07317_ _01641_ _01643_ VSS VSS VDD VDD _01644_ sky130_fd_sc_hd__nand2_1
X_07318_ net58 VSS VSS VDD VDD _01645_ sky130_fd_sc_hd__inv_1
X_07319_ _01644_ _01645_ VSS VSS VDD VDD _01646_ sky130_fd_sc_hd__nand2_1
X_07320_ _01646_ VSS VSS VDD VDD _01647_ sky130_fd_sc_hd__inv_1
X_07321_ _00969_ VSS VSS VDD VDD _01648_ sky130_fd_sc_hd__inv_1
X_07322_ _01012_ _01648_ VSS VSS VDD VDD _01649_ sky130_fd_sc_hd__nand2_1
X_07323_ _01011_ _00969_ VSS VSS VDD VDD _01650_ sky130_fd_sc_hd__nand2_1
X_07324_ net57 VSS VSS VDD VDD _01651_ sky130_fd_sc_hd__inv_1
X_07325_ _01649_ _01650_ _01651_ VSS VSS VDD VDD _01652_ sky130_fd_sc_hd__nand3_1
X_07326_ _01523_ _01008_ VSS VSS VDD VDD _01653_ sky130_fd_sc_hd__nand2_1
X_07327_ _01521_ _01522_ _01009_ VSS VSS VDD VDD _01654_ sky130_fd_sc_hd__nand3_1
X_07328_ net56 VSS VSS VDD VDD _01655_ sky130_fd_sc_hd__inv_1
X_07329_ _01653_ _01654_ _01655_ VSS VSS VDD VDD _01656_ sky130_fd_sc_hd__nand3_1
X_07330_ _01007_ _00990_ VSS VSS VDD VDD _01657_ sky130_fd_sc_hd__nand2_1
X_07331_ _01657_ _01004_ VSS VSS VDD VDD _01658_ sky130_fd_sc_hd__nand2_1
X_07332_ _01008_ _01658_ net55 VSS VSS VDD VDD _01659_ sky130_fd_sc_hd__a21o_1
X_07333_ net54 VSS VSS VDD VDD _01660_ sky130_fd_sc_hd__inv_1
X_07334_ _00992_ _00999_ _01002_ VSS VSS VDD VDD _01661_ sky130_fd_sc_hd__nand3_1
X_07335_ _01004_ _01661_ VSS VSS VDD VDD _01662_ sky130_fd_sc_hd__nand2_1
X_07336_ _01660_ _01662_ VSS VSS VDD VDD _01663_ sky130_fd_sc_hd__nor2_1
X_07337_ _01004_ _01661_ net54 VSS VSS VDD VDD _01664_ sky130_fd_sc_hd__a21oi_1
X_07338_ _01663_ _01664_ VSS VSS VDD VDD _01665_ sky130_fd_sc_hd__nor2_1
X_07339_ net53 VSS VSS VDD VDD _01666_ sky130_fd_sc_hd__inv_1
X_07340_ _01000_ _00944_ VSS VSS VDD VDD _01667_ sky130_fd_sc_hd__nand2_1
X_07341_ _01002_ _01667_ VSS VSS VDD VDD _01668_ sky130_fd_sc_hd__nand2_1
X_07342_ net48 VSS VSS VDD VDD _01669_ sky130_fd_sc_hd__inv_1
X_07343_ net8 net17 VSS VSS VDD VDD _01670_ sky130_fd_sc_hd__nand2_1
X_07344_ net1 net24 VSS VSS VDD VDD _01671_ sky130_fd_sc_hd__nand2_1
X_07345_ _01670_ _01671_ VSS VSS VDD VDD _01672_ sky130_fd_sc_hd__nand2_1
X_07346_ _00997_ _01672_ VSS VSS VDD VDD _01673_ sky130_fd_sc_hd__nand2_1
X_07347_ _01669_ _01673_ VSS VSS VDD VDD _01674_ sky130_fd_sc_hd__nor2_1
X_07348_ net37 VSS VSS VDD VDD _01675_ sky130_fd_sc_hd__inv_1
X_07349_ _01673_ VSS VSS VDD VDD _01676_ sky130_fd_sc_hd__inv_1
X_07350_ net48 _01676_ VSS VSS VDD VDD _01677_ sky130_fd_sc_hd__nor2_1
X_07351_ _01675_ _00995_ _01674_ _01677_ VSS VSS VDD VDD _01678_
+ sky130_fd_sc_hd__nor4_1
X_07352_ _01666_ _01668_ VSS VSS VDD VDD _01679_ sky130_fd_sc_hd__nor2_1
X_07353_ _01002_ _01667_ net53 VSS VSS VDD VDD _01680_ sky130_fd_sc_hd__a21oi_1
X_07354_ _01679_ _01680_ VSS VSS VDD VDD _01681_ sky130_fd_sc_hd__nor2_1
X_07355_ _01674_ _01678_ _01681_ VSS VSS VDD VDD _01682_ sky130_fd_sc_hd__o21ai_0
X_07356_ _01666_ _01668_ _01682_ VSS VSS VDD VDD _01683_ sky130_fd_sc_hd__o21ai_0
X_07357_ _01665_ _01683_ VSS VSS VDD VDD _01684_ sky130_fd_sc_hd__nand2_1
X_07358_ _01663_ VSS VSS VDD VDD _01685_ sky130_fd_sc_hd__inv_1
X_07359_ _01684_ _01685_ VSS VSS VDD VDD _01686_ sky130_fd_sc_hd__nand2_1
X_07360_ _01659_ _01686_ VSS VSS VDD VDD _01687_ sky130_fd_sc_hd__nand2_1
X_07361_ _01008_ _01658_ VSS VSS VDD VDD _01688_ sky130_fd_sc_hd__and2_1
X_07362_ _01688_ net55 VSS VSS VDD VDD _01689_ sky130_fd_sc_hd__nand2_1
X_07363_ _01687_ _01689_ VSS VSS VDD VDD _01690_ sky130_fd_sc_hd__nand2_1
X_07364_ _01656_ _01690_ VSS VSS VDD VDD _01691_ sky130_fd_sc_hd__nand2_1
X_07365_ _01653_ _01654_ VSS VSS VDD VDD _01692_ sky130_fd_sc_hd__nand2_1
X_07366_ _01692_ net56 VSS VSS VDD VDD _01693_ sky130_fd_sc_hd__nand2_1
X_07367_ _01691_ _01693_ VSS VSS VDD VDD _01694_ sky130_fd_sc_hd__nand2_1
X_07368_ _01652_ _01694_ VSS VSS VDD VDD _01695_ sky130_fd_sc_hd__nand2_1
X_07369_ _01649_ _01650_ VSS VSS VDD VDD _01696_ sky130_fd_sc_hd__nand2_1
X_07370_ _01696_ net57 VSS VSS VDD VDD _01697_ sky130_fd_sc_hd__nand2_1
X_07371_ _01695_ _01697_ VSS VSS VDD VDD _01698_ sky130_fd_sc_hd__nand2_1
X_07372_ _01641_ _01643_ net58 VSS VSS VDD VDD _01699_ sky130_fd_sc_hd__nand3_1
X_07373_ _01699_ VSS VSS VDD VDD _01700_ sky130_fd_sc_hd__inv_1
X_07374_ _01698_ _01700_ VSS VSS VDD VDD _01701_ sky130_fd_sc_hd__nor2_1
X_07375_ _01647_ _01701_ VSS VSS VDD VDD _01702_ sky130_fd_sc_hd__nor2_1
X_07376_ _01019_ _01186_ VSS VSS VDD VDD _01703_ sky130_fd_sc_hd__nand2_1
X_07377_ _01186_ _01013_ _01018_ VSS VSS VDD VDD _01704_ sky130_fd_sc_hd__nand3b_1
X_07378_ _01703_ _01704_ VSS VSS VDD VDD _01705_ sky130_fd_sc_hd__nand2_1
X_07379_ _01705_ net59 VSS VSS VDD VDD _01706_ sky130_fd_sc_hd__nand2_1
X_07380_ net59 VSS VSS VDD VDD _01707_ sky130_fd_sc_hd__inv_1
X_07381_ _01703_ _01704_ _01707_ VSS VSS VDD VDD _01708_ sky130_fd_sc_hd__nand3_1
X_07382_ _01706_ _01708_ VSS VSS VDD VDD _01709_ sky130_fd_sc_hd__nand2_1
X_07383_ _01702_ _01709_ VSS VSS VDD VDD _01710_ sky130_fd_sc_hd__nand2_1
X_07384_ _01527_ _01186_ _00927_ VSS VSS VDD VDD _01711_ sky130_fd_sc_hd__nand3_1
X_07385_ _01711_ _01514_ VSS VSS VDD VDD _01712_ sky130_fd_sc_hd__nand2_1
X_07386_ _01712_ _01173_ VSS VSS VDD VDD _01713_ sky130_fd_sc_hd__nand2_1
X_07387_ _01173_ VSS VSS VDD VDD _01714_ sky130_fd_sc_hd__inv_1
X_07388_ _01711_ _01714_ _01514_ VSS VSS VDD VDD _01715_ sky130_fd_sc_hd__nand3_1
X_07389_ _01713_ net60 _01715_ VSS VSS VDD VDD _01716_ sky130_fd_sc_hd__nand3_1
X_07390_ _01703_ _01704_ net59 VSS VSS VDD VDD _01717_ sky130_fd_sc_hd__nand3_1
X_07391_ _01716_ _01717_ VSS VSS VDD VDD _01718_ sky130_fd_sc_hd__nand2_1
X_07392_ _01718_ VSS VSS VDD VDD _01719_ sky130_fd_sc_hd__inv_1
X_07393_ _01710_ _01719_ VSS VSS VDD VDD _01720_ sky130_fd_sc_hd__nand2_1
X_07394_ _01195_ _01335_ VSS VSS VDD VDD _01721_ sky130_fd_sc_hd__nand2_1
X_07395_ _01335_ _01189_ _01194_ VSS VSS VDD VDD _01722_ sky130_fd_sc_hd__nand3b_1
X_07396_ _01721_ _01722_ VSS VSS VDD VDD _01723_ sky130_fd_sc_hd__nand2_1
X_07397_ _01723_ net38 VSS VSS VDD VDD _01724_ sky130_fd_sc_hd__nand2_1
X_07398_ net38 VSS VSS VDD VDD _01725_ sky130_fd_sc_hd__inv_1
X_07399_ _01721_ _01722_ _01725_ VSS VSS VDD VDD _01726_ sky130_fd_sc_hd__nand3_1
X_07400_ _01724_ _01726_ VSS VSS VDD VDD _01727_ sky130_fd_sc_hd__nand2_1
X_07401_ _01713_ _01715_ VSS VSS VDD VDD _01728_ sky130_fd_sc_hd__nand2_1
X_07402_ net60 VSS VSS VDD VDD _01729_ sky130_fd_sc_hd__inv_1
X_07403_ _01728_ _01729_ VSS VSS VDD VDD _01730_ sky130_fd_sc_hd__nand2_1
X_07404_ _01720_ _01727_ _01730_ VSS VSS VDD VDD _01731_ sky130_fd_sc_hd__nand3_1
X_07405_ _01636_ _01637_ net39 VSS VSS VDD VDD _01732_ sky130_fd_sc_hd__nand3_1
X_07406_ _01721_ _01722_ net38 VSS VSS VDD VDD _01733_ sky130_fd_sc_hd__nand3_1
X_07407_ _01732_ _01733_ VSS VSS VDD VDD _01734_ sky130_fd_sc_hd__nand2_1
X_07408_ _01734_ VSS VSS VDD VDD _01735_ sky130_fd_sc_hd__inv_1
X_07409_ _01731_ _01735_ VSS VSS VDD VDD _01736_ sky130_fd_sc_hd__nand2_1
X_07410_ _01635_ _01640_ _01736_ VSS VSS VDD VDD _01737_ sky130_fd_sc_hd__nand3_1
X_07411_ _01633_ _01610_ VSS VSS VDD VDD _01738_ sky130_fd_sc_hd__nand2_1
X_07412_ _01738_ _01632_ VSS VSS VDD VDD _01739_ sky130_fd_sc_hd__nand2_1
X_07413_ _01737_ _01739_ VSS VSS VDD VDD _01740_ sky130_fd_sc_hd__nand2_1
X_07414_ _01597_ _01740_ VSS VSS VDD VDD _01741_ sky130_fd_sc_hd__nand2_1
X_07415_ _01591_ _01741_ VSS VSS VDD VDD _01742_ sky130_fd_sc_hd__nand2_1
X_07416_ net51 VSS VSS VDD VDD _01743_ sky130_fd_sc_hd__inv_1
X_07417_ _01548_ _01743_ VSS VSS VDD VDD _01744_ sky130_fd_sc_hd__nand2_1
X_07418_ _01532_ net51 _01538_ _01546_ VSS VSS VDD VDD _01745_
+ sky130_fd_sc_hd__nand4_1
X_07419_ _01744_ _01745_ VSS VSS VDD VDD _01746_ sky130_fd_sc_hd__nand2_1
X_07420_ _01746_ VSS VSS VDD VDD _01747_ sky130_fd_sc_hd__inv_1
X_07421_ _01742_ _01747_ VSS VSS VDD VDD _01748_ sky130_fd_sc_hd__nand2_1
X_07422_ net35 VSS VSS VDD VDD _01749_ sky130_fd_sc_hd__inv_1
Xoutput46 net46 VSS VSS VDD VDD c00[18] sky130_fd_sc_hd__clkdlybuf4s50_1
X_07424_ _01591_ _01746_ _01741_ VSS VSS VDD VDD _01751_ sky130_fd_sc_hd__nand3_1
X_07425_ _01748_ _01749_ _01751_ VSS VSS VDD VDD _01752_ sky130_fd_sc_hd__nand3_1
Xoutput45 net45 VSS VSS VDD VDD c00[17] sky130_fd_sc_hd__clkdlybuf4s50_1
X_07427_ _01548_ net162 VSS VSS VDD VDD _01754_ sky130_fd_sc_hd__nand2_1
X_07428_ net159 net35 _01754_ VSS VSS VDD VDD _01755_ sky130_fd_sc_hd__o21ai_1
Xoutput44 net44 VSS VSS VDD VDD c00[16] sky130_fd_sc_hd__clkdlybuf4s50_1
Xoutput43 net43 VSS VSS VDD VDD c00[15] sky130_fd_sc_hd__clkdlybuf4s50_1
X_07431_ net162 net51 _00491_ VSS VSS VDD VDD _01758_ sky130_fd_sc_hd__o21ai_0
X_07432_ _01752_ _01755_ _01758_ VSS VSS VDD VDD _00044_ sky130_fd_sc_hd__a21oi_1
X_07433_ _01560_ _01592_ VSS VSS VDD VDD _01759_ sky130_fd_sc_hd__nor2_4
X_07434_ _01759_ VSS VSS VDD VDD _01760_ sky130_fd_sc_hd__inv_1
X_07435_ _01632_ _01508_ _01633_ _01593_ VSS VSS VDD VDD _01761_
+ sky130_fd_sc_hd__nand4_1
X_07436_ _01760_ _01761_ VSS VSS VDD VDD _01762_ sky130_fd_sc_hd__nor2_1
X_07437_ _01585_ _01574_ VSS VSS VDD VDD _01763_ sky130_fd_sc_hd__nor2_1
X_07438_ _01569_ _01556_ VSS VSS VDD VDD _01764_ sky130_fd_sc_hd__nor2_2
X_07439_ _01763_ _01764_ VSS VSS VDD VDD _01765_ sky130_fd_sc_hd__and2_1
X_07440_ _01640_ _01732_ VSS VSS VDD VDD _01766_ sky130_fd_sc_hd__nand2_1
X_07441_ _01615_ _01766_ VSS VSS VDD VDD _01767_ sky130_fd_sc_hd__nor2_1
X_07442_ _01698_ _01646_ _01699_ VSS VSS VDD VDD _01768_ sky130_fd_sc_hd__nand3_1
X_07443_ _01768_ _01717_ _01699_ VSS VSS VDD VDD _01769_ sky130_fd_sc_hd__nand3_1
X_07444_ _01712_ _01714_ VSS VSS VDD VDD _01770_ sky130_fd_sc_hd__nand2_1
X_07445_ _01711_ _01173_ _01514_ VSS VSS VDD VDD _01771_ sky130_fd_sc_hd__nand3_1
X_07446_ _01770_ net60 _01771_ VSS VSS VDD VDD _01772_ sky130_fd_sc_hd__nand3_1
X_07447_ _01713_ _01729_ _01715_ VSS VSS VDD VDD _01773_ sky130_fd_sc_hd__nand3_1
X_07448_ _01772_ _01773_ VSS VSS VDD VDD _01774_ sky130_fd_sc_hd__nand2_1
X_07449_ _01705_ _01707_ VSS VSS VDD VDD _01775_ sky130_fd_sc_hd__nand2_1
X_07450_ _01769_ _01774_ _01775_ VSS VSS VDD VDD _01776_ sky130_fd_sc_hd__nand3_1
X_07451_ _01733_ _01716_ VSS VSS VDD VDD _01777_ sky130_fd_sc_hd__nand2_1
X_07452_ _01777_ VSS VSS VDD VDD _01778_ sky130_fd_sc_hd__inv_1
X_07453_ _01776_ _01778_ VSS VSS VDD VDD _01779_ sky130_fd_sc_hd__nand2_1
X_07454_ _01723_ _01725_ VSS VSS VDD VDD _01780_ sky130_fd_sc_hd__nand2_1
X_07455_ _01767_ _01779_ _01780_ VSS VSS VDD VDD _01781_ sky130_fd_sc_hd__nand3_1
X_07456_ _01732_ _01610_ VSS VSS VDD VDD _01782_ sky130_fd_sc_hd__nand2_1
X_07457_ _01782_ _01614_ VSS VSS VDD VDD _01783_ sky130_fd_sc_hd__nand2_1
X_07458_ _01781_ _01783_ VSS VSS VDD VDD _01784_ sky130_fd_sc_hd__nand2_1
X_07459_ _01762_ _01765_ _01784_ VSS VSS VDD VDD _01785_ sky130_fd_sc_hd__nand3_1
X_07460_ net42 _01507_ VSS VSS VDD VDD _01786_ sky130_fd_sc_hd__nor2_1
X_07461_ _01633_ _01786_ _01508_ VSS VSS VDD VDD _01787_ sky130_fd_sc_hd__o21ai_0
X_07462_ _01787_ _01759_ VSS VSS VDD VDD _01788_ sky130_fd_sc_hd__nand2_1
X_07463_ _01559_ _01547_ VSS VSS VDD VDD _01789_ sky130_fd_sc_hd__nand2_1
X_07464_ _01789_ VSS VSS VDD VDD _01790_ sky130_fd_sc_hd__inv_1
X_07465_ _01788_ _01790_ VSS VSS VDD VDD _01791_ sky130_fd_sc_hd__nand2_1
X_07466_ _01791_ _01765_ VSS VSS VDD VDD _01792_ sky130_fd_sc_hd__nand2_1
X_07467_ net45 net46 net47 net49 _01589_ VSS VSS VDD VDD _01793_
+ sky130_fd_sc_hd__o41ai_1
X_07468_ _01785_ _01792_ _01793_ VSS VSS VDD VDD _01794_ sky130_fd_sc_hd__nand3_1
X_07469_ _01794_ _01581_ VSS VSS VDD VDD _01795_ sky130_fd_sc_hd__nand2_1
X_07470_ _01785_ _01792_ _01580_ _01793_ VSS VSS VDD VDD _01796_
+ sky130_fd_sc_hd__nand4_1
X_07471_ _01795_ _01796_ _01749_ VSS VSS VDD VDD _01797_ sky130_fd_sc_hd__nand3_1
X_07472_ net162 net50 _00491_ VSS VSS VDD VDD _01798_ sky130_fd_sc_hd__o21ai_0
X_07473_ _01797_ _01755_ _01798_ VSS VSS VDD VDD _00045_ sky130_fd_sc_hd__a21oi_1
X_07474_ _01508_ _01547_ VSS VSS VDD VDD _01799_ sky130_fd_sc_hd__nand2_1
X_07475_ _01799_ _01550_ VSS VSS VDD VDD _01800_ sky130_fd_sc_hd__nand2_1
X_07476_ _01800_ _01739_ VSS VSS VDD VDD _01801_ sky130_fd_sc_hd__nand2_1
X_07477_ _01801_ VSS VSS VDD VDD _01802_ sky130_fd_sc_hd__inv_1
X_07478_ _01737_ _01802_ VSS VSS VDD VDD _01803_ sky130_fd_sc_hd__nand2_1
X_07479_ _01556_ _01560_ _01576_ VSS VSS VDD VDD _01804_ sky130_fd_sc_hd__nor3_1
X_07480_ _01592_ _01594_ _01800_ VSS VSS VDD VDD _01805_ sky130_fd_sc_hd__o21ai_0
X_07481_ _01803_ _01804_ _01805_ VSS VSS VDD VDD _01806_ sky130_fd_sc_hd__nand3_1
X_07482_ net44 net45 net46 net47 _01589_ VSS VSS VDD VDD _01807_
+ sky130_fd_sc_hd__o41ai_1
X_07483_ _01806_ _01807_ VSS VSS VDD VDD _01808_ sky130_fd_sc_hd__nand2_1
X_07484_ _01808_ _01586_ VSS VSS VDD VDD _01809_ sky130_fd_sc_hd__nand2_1
X_07485_ _01806_ _01585_ _01807_ VSS VSS VDD VDD _01810_ sky130_fd_sc_hd__nand3_1
X_07486_ _01809_ _01749_ _01810_ VSS VSS VDD VDD _01811_ sky130_fd_sc_hd__nand3_1
X_07487_ net162 net49 _00491_ VSS VSS VDD VDD _01812_ sky130_fd_sc_hd__o21ai_0
X_07488_ _01811_ _01755_ _01812_ VSS VSS VDD VDD _00046_ sky130_fd_sc_hd__a21oi_1
X_07489_ _01508_ VSS VSS VDD VDD _01813_ sky130_fd_sc_hd__inv_1
X_07490_ _01633_ _01786_ VSS VSS VDD VDD _01814_ sky130_fd_sc_hd__nor2_1
X_07491_ _01813_ _01814_ VSS VSS VDD VDD _01815_ sky130_fd_sc_hd__nor2_2
X_07492_ _01815_ _01781_ _01783_ VSS VSS VDD VDD _01816_ sky130_fd_sc_hd__nand3_1
X_07493_ _01761_ _01815_ VSS VSS VDD VDD _01817_ sky130_fd_sc_hd__nand2_1
X_07494_ _01816_ _01817_ _01764_ _01759_ VSS VSS VDD VDD _01818_
+ sky130_fd_sc_hd__nand4_1
X_07495_ net43 net44 net45 net46 _01589_ VSS VSS VDD VDD _01819_
+ sky130_fd_sc_hd__o41ai_1
X_07496_ _01818_ _01819_ VSS VSS VDD VDD _01820_ sky130_fd_sc_hd__nand2_1
X_07497_ _01820_ _01575_ VSS VSS VDD VDD _01821_ sky130_fd_sc_hd__nand2_1
X_07498_ _01818_ _01574_ _01819_ VSS VSS VDD VDD _01822_ sky130_fd_sc_hd__nand3_1
X_07499_ _01821_ _01749_ _01822_ VSS VSS VDD VDD _01823_ sky130_fd_sc_hd__nand3_1
X_07500_ net162 net47 _00491_ VSS VSS VDD VDD _01824_ sky130_fd_sc_hd__o21ai_0
X_07501_ _01823_ _01755_ _01824_ VSS VSS VDD VDD _00047_ sky130_fd_sc_hd__a21oi_1
X_07502_ _01740_ _01561_ _01595_ VSS VSS VDD VDD _01825_ sky130_fd_sc_hd__nand3_1
X_07503_ _01565_ VSS VSS VDD VDD _01826_ sky130_fd_sc_hd__inv_1
X_07504_ _01825_ _01826_ VSS VSS VDD VDD _01827_ sky130_fd_sc_hd__nand2_1
X_07505_ _01827_ _01570_ VSS VSS VDD VDD _01828_ sky130_fd_sc_hd__nand2_1
X_07506_ _01825_ _01569_ _01826_ VSS VSS VDD VDD _01829_ sky130_fd_sc_hd__nand3_1
X_07507_ _01828_ _01749_ _01829_ VSS VSS VDD VDD _01830_ sky130_fd_sc_hd__nand3_1
X_07508_ net162 net46 _00491_ VSS VSS VDD VDD _01831_ sky130_fd_sc_hd__o21ai_0
X_07509_ _01830_ _01755_ _01831_ VSS VSS VDD VDD _00048_ sky130_fd_sc_hd__a21oi_1
X_07510_ _01762_ _01784_ VSS VSS VDD VDD _01832_ sky130_fd_sc_hd__nand2_1
X_07511_ _01791_ VSS VSS VDD VDD _01833_ sky130_fd_sc_hd__inv_1
X_07512_ _01832_ _01833_ VSS VSS VDD VDD _01834_ sky130_fd_sc_hd__nand2_1
X_07513_ _01834_ _01555_ _01554_ VSS VSS VDD VDD _01835_ sky130_fd_sc_hd__nand3_1
X_07514_ _01832_ _01833_ _01556_ VSS VSS VDD VDD _01836_ sky130_fd_sc_hd__nand3_1
X_07515_ _01835_ _01836_ _01749_ VSS VSS VDD VDD _01837_ sky130_fd_sc_hd__nand3_1
Xoutput42 net42 VSS VSS VDD VDD c00[14] sky130_fd_sc_hd__clkdlybuf4s50_1
X_07517_ net162 net45 _00491_ VSS VSS VDD VDD _01839_ sky130_fd_sc_hd__o21ai_0
X_07518_ _01837_ _01755_ _01839_ VSS VSS VDD VDD _00049_ sky130_fd_sc_hd__a21oi_1
X_07519_ _01803_ _01805_ VSS VSS VDD VDD _01840_ sky130_fd_sc_hd__nand2_1
X_07520_ _01560_ _01840_ VSS VSS VDD VDD _01841_ sky130_fd_sc_hd__xor2_1
X_07521_ _01841_ _01749_ VSS VSS VDD VDD _01842_ sky130_fd_sc_hd__nand2_1
X_07522_ net162 net44 _00491_ VSS VSS VDD VDD _01843_ sky130_fd_sc_hd__o21ai_0
X_07523_ _01842_ _01755_ _01843_ VSS VSS VDD VDD _00050_ sky130_fd_sc_hd__a21oi_1
X_07524_ _01816_ _01817_ VSS VSS VDD VDD _01844_ sky130_fd_sc_hd__nand2_1
X_07525_ _01547_ _01550_ _01844_ VSS VSS VDD VDD _01845_ sky130_fd_sc_hd__a21oi_1
X_07526_ _01816_ _01817_ _01592_ VSS VSS VDD VDD _01846_ sky130_fd_sc_hd__a21oi_1
X_07527_ _01845_ _01846_ _01749_ VSS VSS VDD VDD _01847_ sky130_fd_sc_hd__o21ai_0
X_07528_ net162 net43 _00491_ VSS VSS VDD VDD _01848_ sky130_fd_sc_hd__o21ai_0
X_07529_ _01847_ _01755_ _01848_ VSS VSS VDD VDD _00051_ sky130_fd_sc_hd__a21oi_1
X_07530_ _01740_ _01594_ net35 VSS VSS VDD VDD _01849_ sky130_fd_sc_hd__a21oi_1
X_07531_ _01594_ _01740_ _01849_ VSS VSS VDD VDD _01850_ sky130_fd_sc_hd__o21ai_0
X_07532_ _01504_ _01506_ net35 net159 VSS VSS VDD VDD _01851_
+ sky130_fd_sc_hd__a31oi_1
X_07533_ _01850_ _01851_ VSS VSS VDD VDD _01852_ sky130_fd_sc_hd__nand2_1
Xoutput41 net41 VSS VSS VDD VDD c00[13] sky130_fd_sc_hd__clkdlybuf4s50_1
X_07535_ net159 net42 VSS VSS VDD VDD _01854_ sky130_fd_sc_hd__nand2_1
X_07536_ _01852_ _01854_ net34 VSS VSS VDD VDD _00052_ sky130_fd_sc_hd__a21oi_1
X_07537_ _01784_ _01632_ _01633_ VSS VSS VDD VDD _01855_ sky130_fd_sc_hd__nand3_1
X_07538_ _01781_ _01634_ _01783_ VSS VSS VDD VDD _01856_ sky130_fd_sc_hd__nand3_1
X_07539_ net35 net159 VSS VSS VDD VDD _01857_ sky130_fd_sc_hd__nor2_1
Xoutput40 net40 VSS VSS VDD VDD c00[12] sky130_fd_sc_hd__clkdlybuf4s50_1
X_07541_ net162 net35 VSS VSS VDD VDD _01859_ sky130_fd_sc_hd__nand2_1
X_07542_ net162 _01631_ _01859_ _01630_ VSS VSS VDD VDD _01860_
+ sky130_fd_sc_hd__o22ai_1
X_07543_ _01855_ _01856_ _01857_ _01860_ VSS VSS VDD VDD _01861_
+ sky130_fd_sc_hd__a31oi_1
X_07544_ net34 _01861_ VSS VSS VDD VDD _00053_ sky130_fd_sc_hd__nor2_1
X_07545_ net162 _01613_ VSS VSS VDD VDD _01862_ sky130_fd_sc_hd__nor2_1
X_07546_ _01611_ _01612_ _01859_ VSS VSS VDD VDD _01863_ sky130_fd_sc_hd__a21oi_1
X_07547_ _01736_ _01640_ VSS VSS VDD VDD _01864_ sky130_fd_sc_hd__nand2_1
X_07548_ _01615_ _01864_ _01857_ VSS VSS VDD VDD _01865_ sky130_fd_sc_hd__o21ai_0
X_07549_ _01615_ _01864_ _01865_ VSS VSS VDD VDD _01866_ sky130_fd_sc_hd__a21oi_1
X_07550_ _01862_ _01863_ _01866_ net161 VSS VSS VDD VDD _00054_
+ sky130_fd_sc_hd__o31a_1
X_07551_ _01779_ _01780_ VSS VSS VDD VDD _01867_ sky130_fd_sc_hd__nand2_1
X_07552_ _01766_ _01867_ VSS VSS VDD VDD _01868_ sky130_fd_sc_hd__xor2_1
X_07553_ _01638_ net35 VSS VSS VDD VDD _01869_ sky130_fd_sc_hd__nand2_1
X_07554_ net35 _01868_ net162 _01869_ VSS VSS VDD VDD _01870_
+ sky130_fd_sc_hd__o211ai_1
X_07555_ net159 net39 VSS VSS VDD VDD _01871_ sky130_fd_sc_hd__nand2_1
X_07556_ _01870_ _01871_ net34 VSS VSS VDD VDD _00055_ sky130_fd_sc_hd__a21oi_1
X_07557_ net162 _01725_ _01859_ _01723_ VSS VSS VDD VDD _01872_
+ sky130_fd_sc_hd__o22ai_1
X_07558_ _01720_ _01730_ _01727_ VSS VSS VDD VDD _01873_ sky130_fd_sc_hd__a21oi_1
X_07559_ _01731_ _01857_ VSS VSS VDD VDD _01874_ sky130_fd_sc_hd__nand2_1
X_07560_ _01873_ _01874_ VSS VSS VDD VDD _01875_ sky130_fd_sc_hd__nor2_1
X_07561_ _01872_ _01875_ net161 VSS VSS VDD VDD _00056_ sky130_fd_sc_hd__o21a_1
X_07562_ net162 _01729_ _01859_ _01728_ VSS VSS VDD VDD _01876_
+ sky130_fd_sc_hd__o22ai_1
X_07563_ _01769_ _01775_ _01774_ VSS VSS VDD VDD _01877_ sky130_fd_sc_hd__a21oi_1
X_07564_ _01776_ _01857_ VSS VSS VDD VDD _01878_ sky130_fd_sc_hd__nand2_1
X_07565_ _01877_ _01878_ VSS VSS VDD VDD _01879_ sky130_fd_sc_hd__nor2_1
X_07566_ _01876_ _01879_ net161 VSS VSS VDD VDD _00057_ sky130_fd_sc_hd__o21a_1
X_07567_ _01709_ _01702_ VSS VSS VDD VDD _01880_ sky130_fd_sc_hd__or2_2
X_07568_ _01880_ _01710_ _01857_ VSS VSS VDD VDD _01881_ sky130_fd_sc_hd__nand3_1
X_07569_ net162 _01707_ _01859_ _01705_ VSS VSS VDD VDD _01882_
+ sky130_fd_sc_hd__o22ai_1
X_07570_ _01882_ VSS VSS VDD VDD _01883_ sky130_fd_sc_hd__inv_1
Xoutput39 net39 VSS VSS VDD VDD c00[11] sky130_fd_sc_hd__clkdlybuf4s50_1
X_07572_ _01881_ _01883_ net34 VSS VSS VDD VDD _00058_ sky130_fd_sc_hd__a21oi_1
X_07573_ _01700_ _01647_ _01698_ VSS VSS VDD VDD _01885_ sky130_fd_sc_hd__o21bai_1
X_07574_ _01885_ _01857_ _01768_ VSS VSS VDD VDD _01886_ sky130_fd_sc_hd__nand3_1
X_07575_ net159 net58 VSS VSS VDD VDD _01887_ sky130_fd_sc_hd__nand2_1
X_07576_ _01859_ VSS VSS VDD VDD _01888_ sky130_fd_sc_hd__inv_1
X_07577_ _01641_ _01643_ _01888_ VSS VSS VDD VDD _01889_ sky130_fd_sc_hd__nand3_1
X_07578_ _01886_ _01887_ _01889_ net34 VSS VSS VDD VDD _00059_
+ sky130_fd_sc_hd__a31oi_1
X_07579_ _01697_ _01652_ VSS VSS VDD VDD _01890_ sky130_fd_sc_hd__nand2_1
X_07580_ _01890_ VSS VSS VDD VDD _01891_ sky130_fd_sc_hd__inv_1
X_07581_ _01697_ _01652_ _01694_ net35 VSS VSS VDD VDD _01892_
+ sky130_fd_sc_hd__a31oi_1
X_07582_ _01694_ _01891_ _01892_ VSS VSS VDD VDD _01893_ sky130_fd_sc_hd__o21ai_0
Xoutput38 net38 VSS VSS VDD VDD c00[10] sky130_fd_sc_hd__clkdlybuf4s50_1
X_07584_ _01696_ net35 VSS VSS VDD VDD _01895_ sky130_fd_sc_hd__nand2_1
X_07585_ net162 net57 net161 VSS VSS VDD VDD _01896_ sky130_fd_sc_hd__o21ai_0
X_07586_ _01893_ net162 _01895_ _01896_ VSS VSS VDD VDD _00060_
+ sky130_fd_sc_hd__a31oi_1
X_07587_ _01693_ _01656_ _01690_ VSS VSS VDD VDD _01897_ sky130_fd_sc_hd__a21oi_1
X_07588_ net56 _01692_ _01691_ VSS VSS VDD VDD _01898_ sky130_fd_sc_hd__a21oi_1
X_07589_ _01897_ _01898_ _01749_ VSS VSS VDD VDD _01899_ sky130_fd_sc_hd__o21ai_0
X_07590_ _01749_ _01692_ net162 _01899_ VSS VSS VDD VDD _01900_
+ sky130_fd_sc_hd__o211ai_1
X_07591_ net159 net56 VSS VSS VDD VDD _01901_ sky130_fd_sc_hd__nand2_1
X_07592_ _01900_ _01901_ net34 VSS VSS VDD VDD _00061_ sky130_fd_sc_hd__a21oi_1
X_07593_ _01659_ _01689_ VSS VSS VDD VDD _01902_ sky130_fd_sc_hd__nand2_1
X_07594_ _01686_ _01902_ VSS VSS VDD VDD _01903_ sky130_fd_sc_hd__nor2_1
X_07595_ _01689_ _01659_ _01686_ VSS VSS VDD VDD _01904_ sky130_fd_sc_hd__a21boi_0
X_07596_ _01903_ _01904_ _01749_ VSS VSS VDD VDD _01905_ sky130_fd_sc_hd__o21ai_0
X_07597_ _01688_ net35 VSS VSS VDD VDD _01906_ sky130_fd_sc_hd__nand2_1
X_07598_ net162 net55 net161 VSS VSS VDD VDD _01907_ sky130_fd_sc_hd__o21ai_0
X_07599_ _01905_ net162 _01906_ _01907_ VSS VSS VDD VDD _00062_
+ sky130_fd_sc_hd__a31oi_1
X_07600_ _01683_ _01665_ VSS VSS VDD VDD _01908_ sky130_fd_sc_hd__or2_2
X_07601_ _01908_ _01684_ _01857_ VSS VSS VDD VDD _01909_ sky130_fd_sc_hd__nand3_1
X_07602_ net162 _01660_ _01859_ _01662_ VSS VSS VDD VDD _01910_
+ sky130_fd_sc_hd__o22ai_1
X_07603_ _01910_ VSS VSS VDD VDD _01911_ sky130_fd_sc_hd__inv_1
X_07604_ _01909_ _01911_ net34 VSS VSS VDD VDD _00063_ sky130_fd_sc_hd__a21oi_1
X_07605_ net162 _01666_ _01859_ _01668_ VSS VSS VDD VDD _01912_
+ sky130_fd_sc_hd__o22ai_1
X_07606_ _01674_ _01678_ _01681_ VSS VSS VDD VDD _01913_ sky130_fd_sc_hd__nor3_1
X_07607_ _01682_ _01857_ VSS VSS VDD VDD _01914_ sky130_fd_sc_hd__nand2_1
X_07608_ _01913_ _01914_ VSS VSS VDD VDD _01915_ sky130_fd_sc_hd__nor2_1
X_07609_ _01912_ _01915_ net161 VSS VSS VDD VDD _00064_ sky130_fd_sc_hd__o21a_1
X_07610_ _01675_ _00995_ _01674_ _01677_ VSS VSS VDD VDD _01916_
+ sky130_fd_sc_hd__o22ai_1
X_07611_ _01678_ _01749_ _01916_ VSS VSS VDD VDD _01917_ sky130_fd_sc_hd__nand3b_1
X_07612_ _01676_ net35 VSS VSS VDD VDD _01918_ sky130_fd_sc_hd__nand2_1
X_07613_ net162 net48 net161 VSS VSS VDD VDD _01919_ sky130_fd_sc_hd__o21ai_0
X_07614_ _01917_ net162 _01918_ _01919_ VSS VSS VDD VDD _00065_
+ sky130_fd_sc_hd__a31oi_1
X_07615_ net162 net1 net17 VSS VSS VDD VDD _01920_ sky130_fd_sc_hd__nand3_1
X_07616_ _01675_ _01888_ _01920_ VSS VSS VDD VDD _01921_ sky130_fd_sc_hd__nor3_1
X_07617_ _01675_ _01888_ _01920_ VSS VSS VDD VDD _01922_ sky130_fd_sc_hd__o21ai_0
X_07618_ _01922_ net161 VSS VSS VDD VDD _01923_ sky130_fd_sc_hd__nand2_1
X_07619_ _01921_ _01923_ VSS VSS VDD VDD _00066_ sky130_fd_sc_hd__nor2_1
X_07620_ wrapped_design.b00_down\[7\] VSS VSS VDD VDD _01924_
+ sky130_fd_sc_hd__inv_2
X_07621_ wrapped_design.a1_skew\[1\] _01924_ VSS VSS VDD VDD
+ _01925_ sky130_fd_sc_hd__nor2_1
Xoutput37 net37 VSS VSS VDD VDD c00[0] sky130_fd_sc_hd__clkdlybuf4s50_1
X_07623_ wrapped_design.b00_down\[6\] wrapped_design.a1_skew\[2\]
+ VSS VSS VDD VDD _01927_ sky130_fd_sc_hd__nand2_1
X_07624_ _01927_ VSS VSS VDD VDD _01928_ sky130_fd_sc_hd__inv_1
X_07625_ _01925_ _01928_ VSS VSS VDD VDD _01929_ sky130_fd_sc_hd__nand2_1
Xinput36 valid_in VSS VSS VDD VDD net36 sky130_fd_sc_hd__clkdlybuf4s50_1
X_07627_ _00684_ wrapped_design.b00_down\[7\] VSS VSS VDD
+ VDD _01931_ sky130_fd_sc_hd__nand2_1
X_07628_ _01931_ _01927_ VSS VSS VDD VDD _01932_ sky130_fd_sc_hd__nand2_1
X_07629_ _01929_ _01932_ VSS VSS VDD VDD _01933_ sky130_fd_sc_hd__nand2_1
Xinput35 start VSS VSS VDD VDD net35 sky130_fd_sc_hd__clkdlybuf4s50_1
X_07631_ wrapped_design.b00_down\[5\] wrapped_design.a1_skew\[3\]
+ VSS VSS VDD VDD _01935_ sky130_fd_sc_hd__nand2_1
X_07632_ _01935_ VSS VSS VDD VDD _01936_ sky130_fd_sc_hd__inv_1
X_07633_ _01933_ _01936_ VSS VSS VDD VDD _01937_ sky130_fd_sc_hd__nand2_1
X_07634_ _01929_ _01932_ _01935_ VSS VSS VDD VDD _01938_ sky130_fd_sc_hd__nand3_1
X_07635_ _01937_ _01938_ VSS VSS VDD VDD _01939_ sky130_fd_sc_hd__nand2_1
X_07636_ wrapped_design.a1_skew\[0\] _01924_ VSS VSS VDD VDD
+ _01940_ sky130_fd_sc_hd__nor2_1
X_07637_ wrapped_design.b00_down\[6\] wrapped_design.a1_skew\[1\]
+ VSS VSS VDD VDD _01941_ sky130_fd_sc_hd__nand2_2
X_07638_ _01941_ VSS VSS VDD VDD _01942_ sky130_fd_sc_hd__inv_1
X_07639_ _01940_ _01942_ VSS VSS VDD VDD _01943_ sky130_fd_sc_hd__nand2_1
X_07640_ _00687_ wrapped_design.b00_down\[7\] VSS VSS VDD
+ VDD _01944_ sky130_fd_sc_hd__nand2_1
X_07641_ _01944_ _01941_ VSS VSS VDD VDD _01945_ sky130_fd_sc_hd__nand2_1
X_07642_ wrapped_design.b00_down\[5\] wrapped_design.a1_skew\[2\]
+ VSS VSS VDD VDD _01946_ sky130_fd_sc_hd__nand2_1
X_07643_ _01946_ VSS VSS VDD VDD _01947_ sky130_fd_sc_hd__inv_1
X_07644_ _01943_ _01945_ _01947_ VSS VSS VDD VDD _01948_ sky130_fd_sc_hd__nand3_2
X_07645_ _01948_ _01943_ VSS VSS VDD VDD _01949_ sky130_fd_sc_hd__nand2_1
X_07646_ _01939_ _01949_ VSS VSS VDD VDD _01950_ sky130_fd_sc_hd__nand2_1
X_07647_ _01933_ _01935_ VSS VSS VDD VDD _01951_ sky130_fd_sc_hd__nand2_1
X_07648_ _01929_ _01932_ _01936_ VSS VSS VDD VDD _01952_ sky130_fd_sc_hd__nand3_1
X_07649_ _01951_ _01952_ VSS VSS VDD VDD _01953_ sky130_fd_sc_hd__nand2_1
X_07650_ _01943_ VSS VSS VDD VDD _01954_ sky130_fd_sc_hd__inv_1
X_07651_ _01945_ _01947_ _01954_ VSS VSS VDD VDD _01955_ sky130_fd_sc_hd__a21oi_1
X_07652_ _01953_ _01955_ VSS VSS VDD VDD _01956_ sky130_fd_sc_hd__nand2_1
Xinput34 reset VSS VSS VDD VDD net34 sky130_fd_sc_hd__clkdlybuf4s50_1
Xinput33 last VSS VSS VDD VDD net33 sky130_fd_sc_hd__clkdlybuf4s50_1
X_07655_ wrapped_design.b00_down\[3\] wrapped_design.b00_down\[4\]
+ wrapped_design.a1_skew\[4\] wrapped_design.a1_skew\[5\] VSS
+ VSS VDD VDD _01959_ sky130_fd_sc_hd__nand4_2
X_07656_ wrapped_design.b00_down\[3\] wrapped_design.a1_skew\[5\]
+ VSS VSS VDD VDD _01960_ sky130_fd_sc_hd__nand2_1
X_07657_ wrapped_design.b00_down\[4\] wrapped_design.a1_skew\[4\]
+ VSS VSS VDD VDD _01961_ sky130_fd_sc_hd__nand2_2
X_07658_ _01960_ _01961_ VSS VSS VDD VDD _01962_ sky130_fd_sc_hd__nand2_1
X_07659_ _01959_ _01962_ VSS VSS VDD VDD _01963_ sky130_fd_sc_hd__nand2_1
Xinput32 b_top[9] VSS VSS VDD VDD net32 sky130_fd_sc_hd__clkdlybuf4s50_1
X_07661_ wrapped_design.b00_down\[2\] wrapped_design.a1_skew\[6\]
+ VSS VSS VDD VDD _01965_ sky130_fd_sc_hd__nand2_1
X_07662_ _01963_ _01965_ VSS VSS VDD VDD _01966_ sky130_fd_sc_hd__nand2_1
X_07663_ _01965_ VSS VSS VDD VDD _01967_ sky130_fd_sc_hd__inv_1
X_07664_ _01959_ _01967_ _01962_ VSS VSS VDD VDD _01968_ sky130_fd_sc_hd__nand3_1
X_07665_ _01966_ _01968_ VSS VSS VDD VDD _01969_ sky130_fd_sc_hd__nand2_1
X_07666_ _01969_ VSS VSS VDD VDD _01970_ sky130_fd_sc_hd__inv_2
X_07667_ _01950_ _01956_ _01970_ VSS VSS VDD VDD _01971_ sky130_fd_sc_hd__nand3_1
X_07668_ _01953_ _01949_ VSS VSS VDD VDD _01972_ sky130_fd_sc_hd__nand2_1
X_07669_ _01939_ _01955_ VSS VSS VDD VDD _01973_ sky130_fd_sc_hd__nand2_1
X_07670_ _01972_ _01973_ _01969_ VSS VSS VDD VDD _01974_ sky130_fd_sc_hd__nand3_1
X_07671_ _01971_ _01974_ VSS VSS VDD VDD _01975_ sky130_fd_sc_hd__nand2_1
X_07672_ _01940_ _01941_ VSS VSS VDD VDD _01976_ sky130_fd_sc_hd__nand2_1
X_07673_ _01942_ _01944_ VSS VSS VDD VDD _01977_ sky130_fd_sc_hd__nand2_1
X_07674_ _01976_ _01977_ _01946_ VSS VSS VDD VDD _01978_ sky130_fd_sc_hd__nand3_1
X_07675_ _01978_ _01948_ VSS VSS VDD VDD _01979_ sky130_fd_sc_hd__nand2_1
X_07676_ wrapped_design.b00_down\[5\] wrapped_design.a1_skew\[0\]
+ VSS VSS VDD VDD _01980_ sky130_fd_sc_hd__nand2_1
X_07677_ _01941_ _01980_ VSS VSS VDD VDD _01981_ sky130_fd_sc_hd__nor2_1
X_07678_ _01981_ VSS VSS VDD VDD _01982_ sky130_fd_sc_hd__inv_1
X_07679_ _01979_ _01982_ VSS VSS VDD VDD _01983_ sky130_fd_sc_hd__nand2_1
X_07680_ wrapped_design.b00_down\[3\] wrapped_design.a1_skew\[3\]
+ VSS VSS VDD VDD _01984_ sky130_fd_sc_hd__nand2_4
X_07681_ _01961_ _01984_ VSS VSS VDD VDD _01985_ sky130_fd_sc_hd__nor2_2
X_07682_ wrapped_design.b00_down\[3\] wrapped_design.a1_skew\[4\]
+ VSS VSS VDD VDD _01986_ sky130_fd_sc_hd__nand2_1
X_07683_ wrapped_design.b00_down\[4\] wrapped_design.a1_skew\[3\]
+ VSS VSS VDD VDD _01987_ sky130_fd_sc_hd__nand2_1
X_07684_ _01986_ _01987_ VSS VSS VDD VDD _01988_ sky130_fd_sc_hd__nand2_2
X_07685_ _01988_ VSS VSS VDD VDD _01989_ sky130_fd_sc_hd__inv_2
X_07686_ _01985_ _01989_ VSS VSS VDD VDD _01990_ sky130_fd_sc_hd__nor2_2
X_07687_ wrapped_design.b00_down\[2\] wrapped_design.a1_skew\[5\]
+ VSS VSS VDD VDD _01991_ sky130_fd_sc_hd__nand2_1
X_07688_ _01990_ _01991_ VSS VSS VDD VDD _01992_ sky130_fd_sc_hd__nand2_1
X_07689_ _01961_ _01984_ _01988_ VSS VSS VDD VDD _01993_ sky130_fd_sc_hd__o21ai_1
X_07690_ _01991_ VSS VSS VDD VDD _01994_ sky130_fd_sc_hd__inv_1
X_07691_ _01993_ _01994_ VSS VSS VDD VDD _01995_ sky130_fd_sc_hd__nand2_1
X_07692_ _01992_ _01995_ VSS VSS VDD VDD _01996_ sky130_fd_sc_hd__nand2_2
X_07693_ _01982_ _01979_ VSS VSS VDD VDD _01997_ sky130_fd_sc_hd__nor2_1
X_07694_ _01983_ _01996_ _01997_ VSS VSS VDD VDD _01998_ sky130_fd_sc_hd__a21oi_2
X_07695_ _01998_ VSS VSS VDD VDD _01999_ sky130_fd_sc_hd__inv_2
X_07696_ _01975_ _01999_ VSS VSS VDD VDD _02000_ sky130_fd_sc_hd__nand2_1
X_07697_ _01998_ _01971_ _01974_ VSS VSS VDD VDD _02001_ sky130_fd_sc_hd__nand3_1
Xinput31 b_top[8] VSS VSS VDD VDD net31 sky130_fd_sc_hd__clkdlybuf4s50_1
Xinput30 b_top[7] VSS VSS VDD VDD net30 sky130_fd_sc_hd__clkdlybuf4s50_1
X_07700_ wrapped_design.a1_skew\[7\] wrapped_design.b00_down\[0\]
+ VSS VSS VDD VDD _02004_ sky130_fd_sc_hd__nand2_1
Xinput29 b_top[6] VSS VSS VDD VDD net29 sky130_fd_sc_hd__clkdlybuf4s50_1
X_07702_ wrapped_design.b00_down\[1\] wrapped_design.a1_skew\[6\]
+ VSS VSS VDD VDD _02006_ sky130_fd_sc_hd__nand2_1
X_07703_ _02004_ _02006_ VSS VSS VDD VDD _02007_ sky130_fd_sc_hd__nand2_1
X_07704_ _02004_ _02006_ VSS VSS VDD VDD _02008_ sky130_fd_sc_hd__nor2_1
X_07705_ _02007_ wrapped_design.b00_down\[7\] _02008_ VSS
+ VSS VDD VDD _02009_ sky130_fd_sc_hd__a21oi_1
X_07706_ _02009_ VSS VSS VDD VDD _02010_ sky130_fd_sc_hd__inv_1
X_07707_ wrapped_design.b00_down\[0\] VSS VSS VDD VDD _02011_
+ sky130_fd_sc_hd__inv_1
X_07708_ wrapped_design.a1_skew\[7\] wrapped_design.b00_down\[1\]
+ VSS VSS VDD VDD _02012_ sky130_fd_sc_hd__nand2_1
X_07709_ _02012_ _02004_ VSS VSS VDD VDD _02013_ sky130_fd_sc_hd__nand2_1
X_07710_ _02011_ _02012_ _02013_ VSS VSS VDD VDD _02014_ sky130_fd_sc_hd__o21ai_1
X_07711_ _01988_ _01994_ _01985_ VSS VSS VDD VDD _02015_ sky130_fd_sc_hd__a21oi_1
X_07712_ _02014_ _02015_ VSS VSS VDD VDD _02016_ sky130_fd_sc_hd__nor2_1
X_07713_ _02015_ _02014_ VSS VSS VDD VDD _02017_ sky130_fd_sc_hd__nand2_1
X_07714_ _02017_ VSS VSS VDD VDD _02018_ sky130_fd_sc_hd__inv_1
X_07715_ _02016_ _02018_ VSS VSS VDD VDD _02019_ sky130_fd_sc_hd__nor2_1
X_07716_ _02010_ _02019_ VSS VSS VDD VDD _02020_ sky130_fd_sc_hd__nor2_1
X_07717_ _02019_ _02010_ VSS VSS VDD VDD _02021_ sky130_fd_sc_hd__nand2_1
X_07718_ _02021_ VSS VSS VDD VDD _02022_ sky130_fd_sc_hd__inv_2
X_07719_ _02020_ _02022_ VSS VSS VDD VDD _02023_ sky130_fd_sc_hd__nor2_1
X_07720_ _02000_ _02001_ _02023_ VSS VSS VDD VDD _02024_ sky130_fd_sc_hd__nand3_1
X_07721_ _01972_ _01973_ _01970_ VSS VSS VDD VDD _02025_ sky130_fd_sc_hd__nand3_1
X_07722_ _01950_ _01956_ _01969_ VSS VSS VDD VDD _02026_ sky130_fd_sc_hd__nand3_1
X_07723_ _02025_ _02026_ VSS VSS VDD VDD _02027_ sky130_fd_sc_hd__nand2_1
X_07724_ _02027_ _01999_ VSS VSS VDD VDD _02028_ sky130_fd_sc_hd__nand2_2
X_07725_ _01998_ _02025_ _02026_ VSS VSS VDD VDD _02029_ sky130_fd_sc_hd__nand3_2
X_07726_ _02020_ VSS VSS VDD VDD _02030_ sky130_fd_sc_hd__inv_1
X_07727_ _02030_ _02021_ VSS VSS VDD VDD _02031_ sky130_fd_sc_hd__nand2_1
X_07728_ _02028_ _02029_ _02031_ VSS VSS VDD VDD _02032_ sky130_fd_sc_hd__nand3_1
X_07729_ _02024_ _02032_ VSS VSS VDD VDD _02033_ sky130_fd_sc_hd__nand2_1
X_07730_ _01978_ _01948_ _01981_ VSS VSS VDD VDD _02034_ sky130_fd_sc_hd__nand3_1
X_07731_ _01983_ _02034_ _01996_ VSS VSS VDD VDD _02035_ sky130_fd_sc_hd__nand3_2
X_07732_ _01979_ _01981_ VSS VSS VDD VDD _02036_ sky130_fd_sc_hd__nand2_1
X_07733_ _01978_ _01948_ _01982_ VSS VSS VDD VDD _02037_ sky130_fd_sc_hd__nand3_1
X_07734_ _01990_ _01994_ VSS VSS VDD VDD _02038_ sky130_fd_sc_hd__nand2_1
X_07735_ _01993_ _01991_ VSS VSS VDD VDD _02039_ sky130_fd_sc_hd__nand2_1
X_07736_ _02038_ _02039_ VSS VSS VDD VDD _02040_ sky130_fd_sc_hd__nand2_1
X_07737_ _02036_ _02037_ _02040_ VSS VSS VDD VDD _02041_ sky130_fd_sc_hd__nand3_1
X_07738_ _02035_ _02041_ VSS VSS VDD VDD _02042_ sky130_fd_sc_hd__nand2_1
X_07739_ _01987_ VSS VSS VDD VDD _02043_ sky130_fd_sc_hd__inv_2
X_07740_ wrapped_design.b00_down\[3\] wrapped_design.a1_skew\[2\]
+ VSS VSS VDD VDD _02044_ sky130_fd_sc_hd__nand2_2
X_07741_ _02044_ VSS VSS VDD VDD _02045_ sky130_fd_sc_hd__inv_2
X_07742_ _02043_ _02045_ VSS VSS VDD VDD _02046_ sky130_fd_sc_hd__nand2_2
X_07743_ wrapped_design.b00_down\[4\] wrapped_design.a1_skew\[2\]
+ VSS VSS VDD VDD _02047_ sky130_fd_sc_hd__nand2_1
X_07744_ _01984_ _02047_ VSS VSS VDD VDD _02048_ sky130_fd_sc_hd__nand2_2
X_07745_ _02046_ _02048_ VSS VSS VDD VDD _02049_ sky130_fd_sc_hd__nand2_1
X_07746_ wrapped_design.b00_down\[2\] wrapped_design.a1_skew\[4\]
+ VSS VSS VDD VDD _02050_ sky130_fd_sc_hd__nand2_1
X_07747_ _02049_ _02050_ VSS VSS VDD VDD _02051_ sky130_fd_sc_hd__nand2_1
X_07748_ _02050_ VSS VSS VDD VDD _02052_ sky130_fd_sc_hd__inv_1
X_07749_ _02046_ _02052_ _02048_ VSS VSS VDD VDD _02053_ sky130_fd_sc_hd__nand3_2
X_07750_ wrapped_design.b00_down\[5\] wrapped_design.a1_skew\[1\]
+ VSS VSS VDD VDD _02054_ sky130_fd_sc_hd__nand2_1
X_07751_ wrapped_design.b00_down\[6\] wrapped_design.a1_skew\[0\]
+ VSS VSS VDD VDD _02055_ sky130_fd_sc_hd__nand2_1
X_07752_ _02054_ _02055_ VSS VSS VDD VDD _02056_ sky130_fd_sc_hd__nand2_1
X_07753_ _02056_ VSS VSS VDD VDD _02057_ sky130_fd_sc_hd__inv_1
X_07754_ _01981_ _02057_ VSS VSS VDD VDD _02058_ sky130_fd_sc_hd__nor2_1
X_07755_ _02051_ _02053_ _02058_ VSS VSS VDD VDD _02059_ sky130_fd_sc_hd__nand3_2
X_07756_ _02042_ _02059_ VSS VSS VDD VDD _02060_ sky130_fd_sc_hd__nand2_2
X_07757_ _02053_ _02046_ VSS VSS VDD VDD _02061_ sky130_fd_sc_hd__nand2_1
X_07758_ _02007_ VSS VSS VDD VDD _02062_ sky130_fd_sc_hd__inv_1
X_07759_ _02008_ _02062_ VSS VSS VDD VDD _02063_ sky130_fd_sc_hd__nor2_1
X_07760_ _02063_ wrapped_design.b00_down\[7\] VSS VSS VDD
+ VDD _02064_ sky130_fd_sc_hd__nand2_1
X_07761_ wrapped_design.b00_down\[0\] wrapped_design.a1_skew\[6\]
+ VSS VSS VDD VDD _02065_ sky130_fd_sc_hd__nand2_1
X_07762_ _02012_ _02065_ _02007_ VSS VSS VDD VDD _02066_ sky130_fd_sc_hd__o21ai_0
X_07763_ _02066_ _01924_ VSS VSS VDD VDD _02067_ sky130_fd_sc_hd__nand2_1
X_07764_ _02061_ _02064_ _02067_ VSS VSS VDD VDD _02068_ sky130_fd_sc_hd__nand3_2
X_07765_ _02064_ _02067_ VSS VSS VDD VDD _02069_ sky130_fd_sc_hd__nand2_1
X_07766_ _02052_ _02048_ _02046_ VSS VSS VDD VDD _02070_ sky130_fd_sc_hd__a21boi_0
X_07767_ _02069_ _02070_ VSS VSS VDD VDD _02071_ sky130_fd_sc_hd__nand2_1
X_07768_ _02068_ _02071_ VSS VSS VDD VDD _02072_ sky130_fd_sc_hd__nand2_1
X_07769_ wrapped_design.b00_down\[0\] wrapped_design.a1_skew\[5\]
+ VSS VSS VDD VDD _02073_ sky130_fd_sc_hd__nand2_1
X_07770_ _02006_ _02073_ VSS VSS VDD VDD _02074_ sky130_fd_sc_hd__nor2_2
X_07771_ _02072_ _02074_ VSS VSS VDD VDD _02075_ sky130_fd_sc_hd__nand2_1
X_07772_ _02074_ VSS VSS VDD VDD _02076_ sky130_fd_sc_hd__inv_1
X_07773_ _02068_ _02071_ _02076_ VSS VSS VDD VDD _02077_ sky130_fd_sc_hd__nand3_1
X_07774_ _02075_ _02077_ VSS VSS VDD VDD _02078_ sky130_fd_sc_hd__nand2_1
X_07775_ _02059_ VSS VSS VDD VDD _02079_ sky130_fd_sc_hd__inv_1
X_07776_ _02035_ _02041_ _02079_ VSS VSS VDD VDD _02080_ sky130_fd_sc_hd__nand3_1
X_07777_ _02080_ VSS VSS VDD VDD _02081_ sky130_fd_sc_hd__inv_1
X_07778_ _02060_ _02078_ _02081_ VSS VSS VDD VDD _02082_ sky130_fd_sc_hd__a21oi_4
X_07779_ _02082_ VSS VSS VDD VDD _02083_ sky130_fd_sc_hd__inv_2
X_07780_ _02033_ _02083_ VSS VSS VDD VDD _02084_ sky130_fd_sc_hd__nand2_1
X_07781_ _02082_ _02024_ _02032_ VSS VSS VDD VDD _02085_ sky130_fd_sc_hd__nand3_1
X_07782_ _02068_ _02071_ _02074_ VSS VSS VDD VDD _02086_ sky130_fd_sc_hd__nand3_1
X_07783_ _02086_ _02068_ VSS VSS VDD VDD _02087_ sky130_fd_sc_hd__nand2_1
X_07784_ _02084_ _02085_ _02087_ VSS VSS VDD VDD _02088_ sky130_fd_sc_hd__nand3_1
X_07785_ _02028_ _02029_ _02023_ VSS VSS VDD VDD _02089_ sky130_fd_sc_hd__nand3_1
X_07786_ _02000_ _02001_ _02031_ VSS VSS VDD VDD _02090_ sky130_fd_sc_hd__nand3_1
X_07787_ _02089_ _02090_ VSS VSS VDD VDD _02091_ sky130_fd_sc_hd__nand2_1
X_07788_ _02091_ _02083_ VSS VSS VDD VDD _02092_ sky130_fd_sc_hd__nand2_1
X_07789_ _02082_ _02089_ _02090_ VSS VSS VDD VDD _02093_ sky130_fd_sc_hd__nand3_1
X_07790_ _02087_ VSS VSS VDD VDD _02094_ sky130_fd_sc_hd__inv_1
X_07791_ _02092_ _02093_ _02094_ VSS VSS VDD VDD _02095_ sky130_fd_sc_hd__nand3_1
X_07792_ _02088_ _02095_ VSS VSS VDD VDD _02096_ sky130_fd_sc_hd__nand2_1
X_07793_ _02060_ _02080_ _02078_ VSS VSS VDD VDD _02097_ sky130_fd_sc_hd__nand3_1
X_07794_ _02042_ _02079_ VSS VSS VDD VDD _02098_ sky130_fd_sc_hd__nand2_1
X_07795_ _02035_ _02041_ _02059_ VSS VSS VDD VDD _02099_ sky130_fd_sc_hd__nand3_1
X_07796_ _02072_ _02076_ VSS VSS VDD VDD _02100_ sky130_fd_sc_hd__nand2_1
X_07797_ _02100_ _02086_ VSS VSS VDD VDD _02101_ sky130_fd_sc_hd__nand2_1
X_07798_ _02098_ _02099_ _02101_ VSS VSS VDD VDD _02102_ sky130_fd_sc_hd__nand3_1
X_07799_ _02097_ _02102_ VSS VSS VDD VDD _02103_ sky130_fd_sc_hd__nand2_1
X_07800_ _02049_ _02052_ VSS VSS VDD VDD _02104_ sky130_fd_sc_hd__nand2_1
X_07801_ _02046_ _02050_ _02048_ VSS VSS VDD VDD _02105_ sky130_fd_sc_hd__nand3_1
X_07802_ _01982_ _02056_ VSS VSS VDD VDD _02106_ sky130_fd_sc_hd__nand2_1
X_07803_ _02104_ _02105_ _02106_ VSS VSS VDD VDD _02107_ sky130_fd_sc_hd__nand3_1
X_07804_ _02059_ _02107_ VSS VSS VDD VDD _02108_ sky130_fd_sc_hd__nand2_1
X_07805_ wrapped_design.b00_down\[4\] wrapped_design.a1_skew\[1\]
+ VSS VSS VDD VDD _02109_ sky130_fd_sc_hd__nand2_1
X_07806_ _02109_ VSS VSS VDD VDD _02110_ sky130_fd_sc_hd__inv_1
X_07807_ _02045_ _02110_ VSS VSS VDD VDD _02111_ sky130_fd_sc_hd__nand2_1
X_07808_ _02044_ _02109_ VSS VSS VDD VDD _02112_ sky130_fd_sc_hd__nand2_1
X_07809_ _02111_ _02112_ VSS VSS VDD VDD _02113_ sky130_fd_sc_hd__nand2_1
X_07810_ wrapped_design.b00_down\[2\] wrapped_design.a1_skew\[3\]
+ VSS VSS VDD VDD _02114_ sky130_fd_sc_hd__nand2_1
X_07811_ _02113_ _02114_ VSS VSS VDD VDD _02115_ sky130_fd_sc_hd__nand2_1
X_07812_ _01980_ VSS VSS VDD VDD _02116_ sky130_fd_sc_hd__inv_1
X_07813_ _02114_ VSS VSS VDD VDD _02117_ sky130_fd_sc_hd__inv_1
X_07814_ _02111_ _02117_ _02112_ VSS VSS VDD VDD _02118_ sky130_fd_sc_hd__nand3_1
X_07815_ _02115_ _02116_ _02118_ VSS VSS VDD VDD _02119_ sky130_fd_sc_hd__nand3_1
X_07816_ _02119_ VSS VSS VDD VDD _02120_ sky130_fd_sc_hd__inv_1
X_07817_ _02108_ _02120_ VSS VSS VDD VDD _02121_ sky130_fd_sc_hd__nand2_1
X_07818_ _02051_ _02053_ _02106_ VSS VSS VDD VDD _02122_ sky130_fd_sc_hd__nand3_1
X_07819_ _02104_ _02105_ _02058_ VSS VSS VDD VDD _02123_ sky130_fd_sc_hd__nand3_1
X_07820_ _02122_ _02123_ VSS VSS VDD VDD _02124_ sky130_fd_sc_hd__nand2_1
X_07821_ _02124_ _02119_ VSS VSS VDD VDD _02125_ sky130_fd_sc_hd__nand2_1
X_07822_ _02121_ _02125_ VSS VSS VDD VDD _02126_ sky130_fd_sc_hd__nand2_1
X_07823_ wrapped_design.b00_down\[3\] wrapped_design.a1_skew\[1\]
+ VSS VSS VDD VDD _02127_ sky130_fd_sc_hd__nand2_1
X_07824_ _02047_ _02127_ VSS VSS VDD VDD _02128_ sky130_fd_sc_hd__nor2_1
X_07825_ _02112_ _02117_ _02128_ VSS VSS VDD VDD _02129_ sky130_fd_sc_hd__a21oi_1
X_07826_ _02129_ VSS VSS VDD VDD _02130_ sky130_fd_sc_hd__inv_1
X_07827_ wrapped_design.b00_down\[1\] wrapped_design.a1_skew\[5\]
+ VSS VSS VDD VDD _02131_ sky130_fd_sc_hd__nand2_1
X_07828_ _02065_ _02131_ VSS VSS VDD VDD _02132_ sky130_fd_sc_hd__nand2_1
X_07829_ _02076_ _02132_ VSS VSS VDD VDD _02133_ sky130_fd_sc_hd__nand2_1
X_07830_ _02130_ _02133_ VSS VSS VDD VDD _02134_ sky130_fd_sc_hd__nand2_1
X_07831_ _02133_ VSS VSS VDD VDD _02135_ sky130_fd_sc_hd__inv_1
X_07832_ _02135_ _02129_ VSS VSS VDD VDD _02136_ sky130_fd_sc_hd__nand2_1
X_07833_ _02134_ _02136_ VSS VSS VDD VDD _02137_ sky130_fd_sc_hd__nand2_1
X_07834_ wrapped_design.b00_down\[0\] wrapped_design.a1_skew\[4\]
+ VSS VSS VDD VDD _02138_ sky130_fd_sc_hd__nand2_1
X_07835_ _02131_ _02138_ VSS VSS VDD VDD _02139_ sky130_fd_sc_hd__nor2_1
X_07836_ _02139_ VSS VSS VDD VDD _02140_ sky130_fd_sc_hd__inv_1
X_07837_ _02137_ _02140_ VSS VSS VDD VDD _02141_ sky130_fd_sc_hd__nand2_1
X_07838_ _02130_ _02135_ VSS VSS VDD VDD _02142_ sky130_fd_sc_hd__nand2_1
X_07839_ _02129_ _02133_ VSS VSS VDD VDD _02143_ sky130_fd_sc_hd__nand2_1
X_07840_ _02142_ _02143_ VSS VSS VDD VDD _02144_ sky130_fd_sc_hd__nand2_1
X_07841_ _02144_ _02139_ VSS VSS VDD VDD _02145_ sky130_fd_sc_hd__nand2_1
X_07842_ _02141_ _02145_ VSS VSS VDD VDD _02146_ sky130_fd_sc_hd__nand2_1
X_07843_ _02126_ _02146_ VSS VSS VDD VDD _02147_ sky130_fd_sc_hd__nand2_1
X_07844_ _02124_ _02120_ VSS VSS VDD VDD _02148_ sky130_fd_sc_hd__nand2_1
X_07845_ _02147_ _02148_ VSS VSS VDD VDD _02149_ sky130_fd_sc_hd__nand2_1
X_07846_ _02149_ VSS VSS VDD VDD _02150_ sky130_fd_sc_hd__inv_1
X_07847_ _02103_ _02150_ VSS VSS VDD VDD _02151_ sky130_fd_sc_hd__nand2_1
X_07848_ _02137_ _02139_ VSS VSS VDD VDD _02152_ sky130_fd_sc_hd__nand2_1
X_07849_ _02152_ _02142_ VSS VSS VDD VDD _02153_ sky130_fd_sc_hd__nand2_1
X_07850_ _02097_ _02102_ _02149_ VSS VSS VDD VDD _02154_ sky130_fd_sc_hd__nand3_1
X_07851_ _02154_ VSS VSS VDD VDD _02155_ sky130_fd_sc_hd__inv_1
X_07852_ _02151_ _02153_ _02155_ VSS VSS VDD VDD _02156_ sky130_fd_sc_hd__a21oi_2
X_07853_ _02156_ VSS VSS VDD VDD _02157_ sky130_fd_sc_hd__inv_1
X_07854_ _02096_ _02157_ VSS VSS VDD VDD _02158_ sky130_fd_sc_hd__nand2_1
X_07855_ _02156_ _02088_ _02095_ VSS VSS VDD VDD _02159_ sky130_fd_sc_hd__nand3_1
X_07856_ _02158_ _02159_ VSS VSS VDD VDD _02160_ sky130_fd_sc_hd__nand2_1
X_07857_ wrapped_design.b00_down\[0\] wrapped_design.a1_skew\[3\]
+ VSS VSS VDD VDD _02161_ sky130_fd_sc_hd__nand2_1
X_07858_ _02161_ VSS VSS VDD VDD _02162_ sky130_fd_sc_hd__inv_1
X_07859_ wrapped_design.b00_down\[1\] wrapped_design.a1_skew\[2\]
+ VSS VSS VDD VDD _02163_ sky130_fd_sc_hd__nand2_1
X_07860_ _02163_ VSS VSS VDD VDD _02164_ sky130_fd_sc_hd__inv_1
X_07861_ _02162_ _02164_ VSS VSS VDD VDD _02165_ sky130_fd_sc_hd__nand2_1
X_07862_ _02161_ _02163_ VSS VSS VDD VDD _02166_ sky130_fd_sc_hd__nand2_1
X_07863_ _02165_ _02166_ VSS VSS VDD VDD _02167_ sky130_fd_sc_hd__nand2_1
X_07864_ _02164_ wrapped_design.b00_down\[0\] wrapped_design.a1_skew\[1\]
+ VSS VSS VDD VDD _02168_ sky130_fd_sc_hd__nand3_1
X_07865_ _02167_ _02168_ VSS VSS VDD VDD _02169_ sky130_fd_sc_hd__nand2_1
X_07866_ wrapped_design.b00_down\[3\] wrapped_design.a1_skew\[0\]
+ VSS VSS VDD VDD _02170_ sky130_fd_sc_hd__nand2_1
X_07867_ wrapped_design.b00_down\[2\] wrapped_design.a1_skew\[1\]
+ VSS VSS VDD VDD _02171_ sky130_fd_sc_hd__nand2_1
X_07868_ _02170_ _02171_ VSS VSS VDD VDD _02172_ sky130_fd_sc_hd__xor2_1
X_07869_ _02164_ wrapped_design.b00_down\[0\] wrapped_design.a1_skew\[1\]
+ _00678_ VSS VSS VDD VDD _02173_ sky130_fd_sc_hd__nand4_1
X_07870_ _02169_ _02172_ _02173_ VSS VSS VDD VDD _02174_ sky130_fd_sc_hd__a21boi_0
X_07871_ wrapped_design.b00_down\[0\] wrapped_design.b00_down\[1\]
+ wrapped_design.a1_skew\[3\] wrapped_design.a1_skew\[4\] VSS
+ VSS VDD VDD _02175_ sky130_fd_sc_hd__nand4_1
X_07872_ wrapped_design.b00_down\[1\] wrapped_design.a1_skew\[3\]
+ VSS VSS VDD VDD _02176_ sky130_fd_sc_hd__nand2_1
X_07873_ _02138_ _02176_ VSS VSS VDD VDD _02177_ sky130_fd_sc_hd__nand2_1
X_07874_ _02175_ _02177_ VSS VSS VDD VDD _02178_ sky130_fd_sc_hd__nand2_1
X_07875_ wrapped_design.b00_down\[2\] wrapped_design.a1_skew\[0\]
+ VSS VSS VDD VDD _02179_ sky130_fd_sc_hd__nand2_1
X_07876_ _02127_ _02179_ VSS VSS VDD VDD _02180_ sky130_fd_sc_hd__nor2_1
X_07877_ _02180_ VSS VSS VDD VDD _02181_ sky130_fd_sc_hd__inv_1
X_07878_ _02178_ _02181_ VSS VSS VDD VDD _02182_ sky130_fd_sc_hd__nand2_1
X_07879_ _02175_ _02180_ _02177_ VSS VSS VDD VDD _02183_ sky130_fd_sc_hd__nand3_1
X_07880_ _02182_ _02183_ _02162_ _02164_ VSS VSS VDD VDD _02184_
+ sky130_fd_sc_hd__nand4_1
X_07881_ _02182_ _02183_ VSS VSS VDD VDD _02185_ sky130_fd_sc_hd__nand2_1
X_07882_ _02185_ _02165_ VSS VSS VDD VDD _02186_ sky130_fd_sc_hd__nand2_1
X_07883_ _02184_ _02186_ VSS VSS VDD VDD _02187_ sky130_fd_sc_hd__nand2_1
X_07884_ wrapped_design.b00_down\[2\] wrapped_design.a1_skew\[2\]
+ VSS VSS VDD VDD _02188_ sky130_fd_sc_hd__nand2_1
X_07885_ _02109_ _02170_ VSS VSS VDD VDD _02189_ sky130_fd_sc_hd__nor2_2
X_07886_ _02189_ VSS VSS VDD VDD _02190_ sky130_fd_sc_hd__inv_1
X_07887_ wrapped_design.b00_down\[4\] wrapped_design.a1_skew\[0\]
+ VSS VSS VDD VDD _02191_ sky130_fd_sc_hd__nand2_1
X_07888_ _02127_ _02191_ VSS VSS VDD VDD _02192_ sky130_fd_sc_hd__nand2_1
X_07889_ _02190_ _02192_ VSS VSS VDD VDD _02193_ sky130_fd_sc_hd__nand2_1
X_07890_ _02188_ _02193_ VSS VSS VDD VDD _02194_ sky130_fd_sc_hd__xor2_1
X_07891_ _02194_ VSS VSS VDD VDD _02195_ sky130_fd_sc_hd__inv_1
X_07892_ _02187_ _02195_ VSS VSS VDD VDD _02196_ sky130_fd_sc_hd__nand2_1
X_07893_ _02184_ _02194_ _02186_ VSS VSS VDD VDD _02197_ sky130_fd_sc_hd__nand3_2
X_07894_ _02174_ _02196_ _02197_ VSS VSS VDD VDD _02198_ sky130_fd_sc_hd__nand3b_1
X_07895_ _02198_ VSS VSS VDD VDD _02199_ sky130_fd_sc_hd__inv_1
X_07896_ _02169_ _02173_ VSS VSS VDD VDD _02200_ sky130_fd_sc_hd__nand2_1
X_07897_ _02172_ _02200_ VSS VSS VDD VDD _02201_ sky130_fd_sc_hd__xor2_1
X_07898_ wrapped_design.b00_down\[1\] wrapped_design.a1_skew\[1\]
+ VSS VSS VDD VDD _02202_ sky130_fd_sc_hd__nand2_1
X_07899_ _02011_ _00681_ _02202_ VSS VSS VDD VDD _02203_ sky130_fd_sc_hd__o21ai_1
X_07900_ _02168_ _02203_ VSS VSS VDD VDD _02204_ sky130_fd_sc_hd__nand2_1
X_07901_ _02202_ VSS VSS VDD VDD _02205_ sky130_fd_sc_hd__inv_1
X_07902_ wrapped_design.b00_down\[0\] wrapped_design.a1_skew\[0\]
+ VSS VSS VDD VDD _02206_ sky130_fd_sc_hd__nand2_1
X_07903_ _02206_ VSS VSS VDD VDD _02207_ sky130_fd_sc_hd__inv_1
X_07904_ _02205_ _02207_ VSS VSS VDD VDD _02208_ sky130_fd_sc_hd__nand2_1
X_07905_ _02204_ _02208_ VSS VSS VDD VDD _02209_ sky130_fd_sc_hd__nand2_1
X_07906_ _02205_ wrapped_design.b00_down\[0\] wrapped_design.a1_skew\[0\]
+ _00681_ VSS VSS VDD VDD _02210_ sky130_fd_sc_hd__nand4_1
X_07907_ _02179_ _02209_ _02210_ VSS VSS VDD VDD _02211_ sky130_fd_sc_hd__nand3b_1
X_07908_ _02211_ _02210_ VSS VSS VDD VDD _02212_ sky130_fd_sc_hd__nand2_1
X_07909_ _02201_ _02212_ VSS VSS VDD VDD _02213_ sky130_fd_sc_hd__nand2b_1
X_07910_ _02196_ _02197_ VSS VSS VDD VDD _02214_ sky130_fd_sc_hd__nand2_1
X_07911_ _02214_ _02174_ VSS VSS VDD VDD _02215_ sky130_fd_sc_hd__nand2_1
X_07912_ _02215_ _02198_ VSS VSS VDD VDD _02216_ sky130_fd_sc_hd__nand2_1
X_07913_ _02213_ _02216_ VSS VSS VDD VDD _02217_ sky130_fd_sc_hd__nor2_2
X_07914_ _02188_ VSS VSS VDD VDD _02218_ sky130_fd_sc_hd__inv_1
X_07915_ _02192_ _02218_ _02189_ VSS VSS VDD VDD _02219_ sky130_fd_sc_hd__a21oi_1
X_07916_ _02219_ VSS VSS VDD VDD _02220_ sky130_fd_sc_hd__inv_1
X_07917_ wrapped_design.b00_down\[1\] wrapped_design.a1_skew\[4\]
+ VSS VSS VDD VDD _02221_ sky130_fd_sc_hd__nand2_1
X_07918_ _02073_ _02221_ VSS VSS VDD VDD _02222_ sky130_fd_sc_hd__nand2_1
X_07919_ _02140_ _02222_ VSS VSS VDD VDD _02223_ sky130_fd_sc_hd__nand2_1
X_07920_ _02223_ VSS VSS VDD VDD _02224_ sky130_fd_sc_hd__inv_1
X_07921_ _02220_ _02224_ VSS VSS VDD VDD _02225_ sky130_fd_sc_hd__nand2_1
X_07922_ _02219_ _02223_ VSS VSS VDD VDD _02226_ sky130_fd_sc_hd__nand2_1
X_07923_ _02225_ _02226_ VSS VSS VDD VDD _02227_ sky130_fd_sc_hd__nand2_1
X_07924_ _02227_ _02175_ VSS VSS VDD VDD _02228_ sky130_fd_sc_hd__nand2_1
X_07925_ _02175_ VSS VSS VDD VDD _02229_ sky130_fd_sc_hd__inv_1
X_07926_ _02225_ _02229_ _02226_ VSS VSS VDD VDD _02230_ sky130_fd_sc_hd__nand3_1
X_07927_ _02115_ _02118_ VSS VSS VDD VDD _02231_ sky130_fd_sc_hd__nand2_1
X_07928_ _02231_ _02116_ VSS VSS VDD VDD _02232_ sky130_fd_sc_hd__nand2_1
X_07929_ _02115_ _01980_ _02118_ VSS VSS VDD VDD _02233_ sky130_fd_sc_hd__nand3_1
X_07930_ _02232_ _02233_ VSS VSS VDD VDD _02234_ sky130_fd_sc_hd__nand2_1
X_07931_ _02228_ _02230_ _02234_ VSS VSS VDD VDD _02235_ sky130_fd_sc_hd__nand3_2
X_07932_ _02197_ VSS VSS VDD VDD _02236_ sky130_fd_sc_hd__inv_1
X_07933_ _02227_ _02229_ VSS VSS VDD VDD _02237_ sky130_fd_sc_hd__nand2_1
X_07934_ _02225_ _02175_ _02226_ VSS VSS VDD VDD _02238_ sky130_fd_sc_hd__nand3_1
X_07935_ _02231_ _01980_ VSS VSS VDD VDD _02239_ sky130_fd_sc_hd__nand2_1
X_07936_ _02239_ _02119_ VSS VSS VDD VDD _02240_ sky130_fd_sc_hd__nand2_1
X_07937_ _02237_ _02238_ _02240_ VSS VSS VDD VDD _02241_ sky130_fd_sc_hd__nand3_1
X_07938_ _02235_ _02236_ _02241_ VSS VSS VDD VDD _02242_ sky130_fd_sc_hd__nand3_1
X_07939_ _02228_ _02230_ _02240_ VSS VSS VDD VDD _02243_ sky130_fd_sc_hd__nand3_1
X_07940_ _02237_ _02238_ _02234_ VSS VSS VDD VDD _02244_ sky130_fd_sc_hd__nand3_1
X_07941_ _02243_ _02244_ _02197_ VSS VSS VDD VDD _02245_ sky130_fd_sc_hd__nand3_1
X_07942_ _02242_ _02245_ VSS VSS VDD VDD _02246_ sky130_fd_sc_hd__nand2_1
X_07943_ _02184_ _02183_ VSS VSS VDD VDD _02247_ sky130_fd_sc_hd__nand2_1
X_07944_ _02246_ _02247_ VSS VSS VDD VDD _02248_ sky130_fd_sc_hd__nand2_1
X_07945_ _02247_ _02242_ _02245_ VSS VSS VDD VDD _02249_ sky130_fd_sc_hd__nand3b_1
X_07946_ _02248_ _02249_ VSS VSS VDD VDD _02250_ sky130_fd_sc_hd__nand2_1
X_07947_ _02199_ _02217_ _02250_ VSS VSS VDD VDD _02251_ sky130_fd_sc_hd__o21ai_2
X_07948_ _02247_ _02245_ _02242_ VSS VSS VDD VDD _02252_ sky130_fd_sc_hd__a21boi_1
X_07949_ _02252_ VSS VSS VDD VDD _02253_ sky130_fd_sc_hd__inv_1
X_07950_ _02108_ _02119_ VSS VSS VDD VDD _02254_ sky130_fd_sc_hd__nand2_1
X_07951_ _02148_ _02254_ VSS VSS VDD VDD _02255_ sky130_fd_sc_hd__nand2_1
X_07952_ _02255_ _02146_ VSS VSS VDD VDD _02256_ sky130_fd_sc_hd__nand2_1
X_07953_ _02144_ _02140_ VSS VSS VDD VDD _02257_ sky130_fd_sc_hd__nand2_1
X_07954_ _02152_ _02257_ VSS VSS VDD VDD _02258_ sky130_fd_sc_hd__nand2_1
X_07955_ _02126_ _02258_ VSS VSS VDD VDD _02259_ sky130_fd_sc_hd__nand2_1
X_07956_ _02235_ VSS VSS VDD VDD _02260_ sky130_fd_sc_hd__inv_1
X_07957_ _02256_ _02259_ _02260_ VSS VSS VDD VDD _02261_ sky130_fd_sc_hd__nand3_1
X_07958_ _02255_ _02258_ VSS VSS VDD VDD _02262_ sky130_fd_sc_hd__nand2_1
X_07959_ _02147_ _02262_ _02235_ VSS VSS VDD VDD _02263_ sky130_fd_sc_hd__nand3_1
X_07960_ _02230_ _02225_ VSS VSS VDD VDD _02264_ sky130_fd_sc_hd__nand2_1
X_07961_ _02261_ _02263_ _02264_ VSS VSS VDD VDD _02265_ sky130_fd_sc_hd__nand3_1
X_07962_ _02147_ _02262_ _02260_ VSS VSS VDD VDD _02266_ sky130_fd_sc_hd__nand3_1
X_07963_ _02256_ _02259_ _02235_ VSS VSS VDD VDD _02267_ sky130_fd_sc_hd__nand3_1
X_07964_ _02264_ VSS VSS VDD VDD _02268_ sky130_fd_sc_hd__inv_1
X_07965_ _02266_ _02267_ _02268_ VSS VSS VDD VDD _02269_ sky130_fd_sc_hd__nand3_1
X_07966_ _02265_ _02269_ VSS VSS VDD VDD _02270_ sky130_fd_sc_hd__nand2_1
X_07967_ _02253_ _02270_ VSS VSS VDD VDD _02271_ sky130_fd_sc_hd__nor2_1
X_07968_ _02270_ _02253_ VSS VSS VDD VDD _02272_ sky130_fd_sc_hd__nand2_1
X_07969_ _02251_ _02271_ _02272_ VSS VSS VDD VDD _02273_ sky130_fd_sc_hd__o21ai_2
X_07970_ _02103_ _02149_ VSS VSS VDD VDD _02274_ sky130_fd_sc_hd__nand2_1
X_07971_ _02150_ _02097_ _02102_ VSS VSS VDD VDD _02275_ sky130_fd_sc_hd__nand3_1
X_07972_ _02274_ _02275_ VSS VSS VDD VDD _02276_ sky130_fd_sc_hd__nand2_1
X_07973_ _02276_ _02153_ VSS VSS VDD VDD _02277_ sky130_fd_sc_hd__nand2_1
X_07974_ _02151_ _02154_ VSS VSS VDD VDD _02278_ sky130_fd_sc_hd__nand2_1
X_07975_ _02153_ VSS VSS VDD VDD _02279_ sky130_fd_sc_hd__inv_1
X_07976_ _02278_ _02279_ VSS VSS VDD VDD _02280_ sky130_fd_sc_hd__nand2_1
X_07977_ _02264_ _02267_ _02266_ VSS VSS VDD VDD _02281_ sky130_fd_sc_hd__a21boi_1
X_07978_ _02277_ _02280_ _02281_ VSS VSS VDD VDD _02282_ sky130_fd_sc_hd__nand3_1
X_07979_ _02276_ _02279_ VSS VSS VDD VDD _02283_ sky130_fd_sc_hd__nand2_1
X_07980_ _02278_ _02153_ VSS VSS VDD VDD _02284_ sky130_fd_sc_hd__nand2_1
X_07981_ _02281_ VSS VSS VDD VDD _02285_ sky130_fd_sc_hd__inv_1
X_07982_ _02283_ _02284_ _02285_ VSS VSS VDD VDD _02286_ sky130_fd_sc_hd__nand3_1
X_07983_ _02282_ _02286_ VSS VSS VDD VDD _02287_ sky130_fd_sc_hd__nand2_1
X_07984_ _02160_ _02273_ _02287_ VSS VSS VDD VDD _02288_ sky130_fd_sc_hd__nand3_1
X_07985_ _02092_ _02093_ _02087_ VSS VSS VDD VDD _02289_ sky130_fd_sc_hd__nand3_1
X_07986_ _02084_ _02085_ _02094_ VSS VSS VDD VDD _02290_ sky130_fd_sc_hd__nand3_1
X_07987_ _02289_ _02290_ VSS VSS VDD VDD _02291_ sky130_fd_sc_hd__nand2_1
X_07988_ _02291_ _02157_ VSS VSS VDD VDD _02292_ sky130_fd_sc_hd__nand2_1
X_07989_ _02277_ _02280_ _02285_ VSS VSS VDD VDD _02293_ sky130_fd_sc_hd__nand3_1
X_07990_ _02292_ _02293_ VSS VSS VDD VDD _02294_ sky130_fd_sc_hd__nand2_1
X_07991_ _02156_ _02289_ _02290_ VSS VSS VDD VDD _02295_ sky130_fd_sc_hd__nand3_1
X_07992_ _02294_ _02295_ VSS VSS VDD VDD _02296_ sky130_fd_sc_hd__nand2_1
X_07993_ _02288_ _02296_ VSS VSS VDD VDD _02297_ sky130_fd_sc_hd__nand2_1
X_07994_ wrapped_design.a1_skew\[2\] _01924_ VSS VSS VDD VDD
+ _02298_ sky130_fd_sc_hd__nor2_1
X_07995_ wrapped_design.b00_down\[6\] wrapped_design.a1_skew\[3\]
+ VSS VSS VDD VDD _02299_ sky130_fd_sc_hd__nand2_1
X_07996_ _02299_ VSS VSS VDD VDD _02300_ sky130_fd_sc_hd__inv_1
X_07997_ _02298_ _02300_ VSS VSS VDD VDD _02301_ sky130_fd_sc_hd__nand2_1
X_07998_ _00681_ wrapped_design.b00_down\[7\] VSS VSS VDD
+ VDD _02302_ sky130_fd_sc_hd__nand2_1
X_07999_ _02302_ _02299_ VSS VSS VDD VDD _02303_ sky130_fd_sc_hd__nand2_1
X_08000_ _02301_ _02303_ VSS VSS VDD VDD _02304_ sky130_fd_sc_hd__nand2_1
X_08001_ wrapped_design.b00_down\[5\] wrapped_design.a1_skew\[4\]
+ VSS VSS VDD VDD _02305_ sky130_fd_sc_hd__nand2_1
X_08002_ _02304_ _02305_ VSS VSS VDD VDD _02306_ sky130_fd_sc_hd__nand2_1
X_08003_ _02305_ VSS VSS VDD VDD _02307_ sky130_fd_sc_hd__inv_1
X_08004_ _02301_ _02303_ _02307_ VSS VSS VDD VDD _02308_ sky130_fd_sc_hd__nand3_1
X_08005_ _02306_ _02308_ VSS VSS VDD VDD _02309_ sky130_fd_sc_hd__nand2_1
X_08006_ _01952_ _01929_ VSS VSS VDD VDD _02310_ sky130_fd_sc_hd__nand2_1
X_08007_ _02309_ _02310_ VSS VSS VDD VDD _02311_ sky130_fd_sc_hd__nand2_1
X_08008_ _02304_ _02307_ VSS VSS VDD VDD _02312_ sky130_fd_sc_hd__nand2_1
X_08009_ _02301_ _02303_ _02305_ VSS VSS VDD VDD _02313_ sky130_fd_sc_hd__nand3_1
X_08010_ _02312_ _02313_ VSS VSS VDD VDD _02314_ sky130_fd_sc_hd__nand2_1
X_08011_ _01929_ VSS VSS VDD VDD _02315_ sky130_fd_sc_hd__inv_1
X_08012_ _01932_ _01936_ _02315_ VSS VSS VDD VDD _02316_ sky130_fd_sc_hd__a21oi_1
X_08013_ _02314_ _02316_ VSS VSS VDD VDD _02317_ sky130_fd_sc_hd__nand2_1
X_08014_ wrapped_design.b00_down\[3\] wrapped_design.b00_down\[4\]
+ wrapped_design.a1_skew\[5\] wrapped_design.a1_skew\[6\] VSS
+ VSS VDD VDD _02318_ sky130_fd_sc_hd__nand4_1
X_08015_ wrapped_design.b00_down\[3\] wrapped_design.a1_skew\[6\]
+ VSS VSS VDD VDD _02319_ sky130_fd_sc_hd__nand2_2
X_08016_ wrapped_design.b00_down\[4\] wrapped_design.a1_skew\[5\]
+ VSS VSS VDD VDD _02320_ sky130_fd_sc_hd__nand2_1
X_08017_ _02319_ _02320_ VSS VSS VDD VDD _02321_ sky130_fd_sc_hd__nand2_1
X_08018_ _02318_ _02321_ VSS VSS VDD VDD _02322_ sky130_fd_sc_hd__nand2_1
X_08019_ wrapped_design.a1_skew\[7\] wrapped_design.b00_down\[2\]
+ VSS VSS VDD VDD _02323_ sky130_fd_sc_hd__nand2_2
X_08020_ _02322_ _02323_ VSS VSS VDD VDD _02324_ sky130_fd_sc_hd__nand2_1
X_08021_ _02323_ VSS VSS VDD VDD _02325_ sky130_fd_sc_hd__inv_2
X_08022_ _02318_ _02325_ _02321_ VSS VSS VDD VDD _02326_ sky130_fd_sc_hd__nand3_1
X_08023_ _02324_ _02326_ VSS VSS VDD VDD _02327_ sky130_fd_sc_hd__nand2_1
X_08024_ _02327_ VSS VSS VDD VDD _02328_ sky130_fd_sc_hd__inv_2
X_08025_ _02311_ _02317_ _02328_ VSS VSS VDD VDD _02329_ sky130_fd_sc_hd__nand3_1
X_08026_ _02314_ _02310_ VSS VSS VDD VDD _02330_ sky130_fd_sc_hd__nand2_1
X_08027_ _02309_ _02316_ VSS VSS VDD VDD _02331_ sky130_fd_sc_hd__nand2_1
X_08028_ _02330_ _02331_ _02327_ VSS VSS VDD VDD _02332_ sky130_fd_sc_hd__nand3_1
X_08029_ _02329_ _02332_ VSS VSS VDD VDD _02333_ sky130_fd_sc_hd__nand2_1
X_08030_ _01971_ _01950_ VSS VSS VDD VDD _02334_ sky130_fd_sc_hd__nand2_1
X_08031_ _02333_ _02334_ VSS VSS VDD VDD _02335_ sky130_fd_sc_hd__nand2_1
X_08032_ _02330_ _02331_ _02328_ VSS VSS VDD VDD _02336_ sky130_fd_sc_hd__nand3_1
X_08033_ _02311_ _02317_ _02327_ VSS VSS VDD VDD _02337_ sky130_fd_sc_hd__nand3_1
X_08034_ _02336_ _02337_ VSS VSS VDD VDD _02338_ sky130_fd_sc_hd__nand2_1
X_08035_ _01950_ VSS VSS VDD VDD _02339_ sky130_fd_sc_hd__inv_1
X_08036_ _01956_ _01970_ _02339_ VSS VSS VDD VDD _02340_ sky130_fd_sc_hd__a21oi_1
X_08037_ _02338_ _02340_ VSS VSS VDD VDD _02341_ sky130_fd_sc_hd__nand2_1
X_08038_ _01968_ _01959_ VSS VSS VDD VDD _02342_ sky130_fd_sc_hd__nand2_1
X_08039_ _02342_ _02013_ VSS VSS VDD VDD _02343_ sky130_fd_sc_hd__nand2_1
X_08040_ _02013_ VSS VSS VDD VDD _02344_ sky130_fd_sc_hd__inv_1
X_08041_ _01968_ _02344_ _01959_ VSS VSS VDD VDD _02345_ sky130_fd_sc_hd__nand3_1
X_08042_ _02343_ _02345_ VSS VSS VDD VDD _02346_ sky130_fd_sc_hd__nand2_1
X_08043_ _02346_ VSS VSS VDD VDD _02347_ sky130_fd_sc_hd__inv_1
X_08044_ _02335_ _02341_ _02347_ VSS VSS VDD VDD _02348_ sky130_fd_sc_hd__nand3_1
X_08045_ _02338_ _02334_ VSS VSS VDD VDD _02349_ sky130_fd_sc_hd__nand2_1
X_08046_ _02333_ _02340_ VSS VSS VDD VDD _02350_ sky130_fd_sc_hd__nand2_1
X_08047_ _02349_ _02350_ _02346_ VSS VSS VDD VDD _02351_ sky130_fd_sc_hd__nand3_1
X_08048_ _02348_ _02351_ VSS VSS VDD VDD _02352_ sky130_fd_sc_hd__nand2_1
X_08049_ _02089_ _02028_ VSS VSS VDD VDD _02353_ sky130_fd_sc_hd__nand2_1
X_08050_ _02352_ _02353_ VSS VSS VDD VDD _02354_ sky130_fd_sc_hd__nand2_1
X_08051_ _02349_ _02350_ _02347_ VSS VSS VDD VDD _02355_ sky130_fd_sc_hd__nand3_1
X_08052_ _02335_ _02341_ _02346_ VSS VSS VDD VDD _02356_ sky130_fd_sc_hd__nand3_1
X_08053_ _02355_ _02356_ VSS VSS VDD VDD _02357_ sky130_fd_sc_hd__nand2_1
X_08054_ _02028_ VSS VSS VDD VDD _02358_ sky130_fd_sc_hd__inv_1
X_08055_ _02029_ _02023_ _02358_ VSS VSS VDD VDD _02359_ sky130_fd_sc_hd__a21oi_1
X_08056_ _02357_ _02359_ VSS VSS VDD VDD _02360_ sky130_fd_sc_hd__nand2_1
X_08057_ _02016_ _02022_ VSS VSS VDD VDD _02361_ sky130_fd_sc_hd__nor2_1
X_08058_ _02361_ VSS VSS VDD VDD _02362_ sky130_fd_sc_hd__inv_1
X_08059_ _02354_ _02360_ _02362_ VSS VSS VDD VDD _02363_ sky130_fd_sc_hd__nand3_1
X_08060_ _02357_ _02353_ VSS VSS VDD VDD _02364_ sky130_fd_sc_hd__nand2_1
X_08061_ _02352_ _02359_ VSS VSS VDD VDD _02365_ sky130_fd_sc_hd__nand2_1
X_08062_ _02364_ _02365_ _02361_ VSS VSS VDD VDD _02366_ sky130_fd_sc_hd__nand3_1
X_08063_ _02363_ _02366_ VSS VSS VDD VDD _02367_ sky130_fd_sc_hd__nand2_1
X_08064_ _02082_ _02091_ VSS VSS VDD VDD _02368_ sky130_fd_sc_hd__nor2_1
X_08065_ _02085_ _02087_ _02368_ VSS VSS VDD VDD _02369_ sky130_fd_sc_hd__a21oi_2
X_08066_ _02369_ VSS VSS VDD VDD _02370_ sky130_fd_sc_hd__inv_2
X_08067_ _02367_ _02370_ VSS VSS VDD VDD _02371_ sky130_fd_sc_hd__nand2_1
X_08068_ _02369_ _02363_ _02366_ VSS VSS VDD VDD _02372_ sky130_fd_sc_hd__nand3_1
X_08069_ _02371_ _02372_ VSS VSS VDD VDD _02373_ sky130_fd_sc_hd__nand2_1
X_08070_ wrapped_design.a1_skew\[3\] _01924_ VSS VSS VDD VDD
+ _02374_ sky130_fd_sc_hd__nor2_1
X_08071_ wrapped_design.b00_down\[6\] wrapped_design.a1_skew\[4\]
+ VSS VSS VDD VDD _02375_ sky130_fd_sc_hd__nand2_1
X_08072_ _02375_ VSS VSS VDD VDD _02376_ sky130_fd_sc_hd__inv_1
X_08073_ _02374_ _02376_ VSS VSS VDD VDD _02377_ sky130_fd_sc_hd__nand2_1
X_08074_ _00678_ wrapped_design.b00_down\[7\] VSS VSS VDD
+ VDD _02378_ sky130_fd_sc_hd__nand2_1
X_08075_ _02378_ _02375_ VSS VSS VDD VDD _02379_ sky130_fd_sc_hd__nand2_1
X_08076_ _02377_ _02379_ VSS VSS VDD VDD _02380_ sky130_fd_sc_hd__nand2_1
X_08077_ wrapped_design.b00_down\[5\] wrapped_design.a1_skew\[5\]
+ VSS VSS VDD VDD _02381_ sky130_fd_sc_hd__nand2_1
X_08078_ _02381_ VSS VSS VDD VDD _02382_ sky130_fd_sc_hd__inv_1
X_08079_ _02380_ _02382_ VSS VSS VDD VDD _02383_ sky130_fd_sc_hd__nand2_1
X_08080_ _02377_ _02379_ _02381_ VSS VSS VDD VDD _02384_ sky130_fd_sc_hd__nand3_1
X_08081_ _02383_ _02384_ VSS VSS VDD VDD _02385_ sky130_fd_sc_hd__nand2_1
X_08082_ _02307_ _02303_ _02301_ VSS VSS VDD VDD _02386_ sky130_fd_sc_hd__a21boi_1
X_08083_ _02385_ _02386_ VSS VSS VDD VDD _02387_ sky130_fd_sc_hd__nand2_1
X_08084_ _02380_ _02381_ VSS VSS VDD VDD _02388_ sky130_fd_sc_hd__nand2_1
X_08085_ _02377_ _02379_ _02382_ VSS VSS VDD VDD _02389_ sky130_fd_sc_hd__nand3_1
X_08086_ _02388_ _02389_ VSS VSS VDD VDD _02390_ sky130_fd_sc_hd__nand2_1
X_08087_ _02308_ _02301_ VSS VSS VDD VDD _02391_ sky130_fd_sc_hd__nand2_1
X_08088_ _02390_ _02391_ VSS VSS VDD VDD _02392_ sky130_fd_sc_hd__nand2_1
X_08089_ wrapped_design.a1_skew\[7\] wrapped_design.b00_down\[4\]
+ VSS VSS VDD VDD _02393_ sky130_fd_sc_hd__nand2_2
X_08090_ wrapped_design.a1_skew\[7\] wrapped_design.b00_down\[3\]
+ VSS VSS VDD VDD _02394_ sky130_fd_sc_hd__nand2_4
X_08091_ wrapped_design.b00_down\[4\] wrapped_design.a1_skew\[6\]
+ VSS VSS VDD VDD _02395_ sky130_fd_sc_hd__nand2_1
X_08092_ _02394_ _02395_ VSS VSS VDD VDD _02396_ sky130_fd_sc_hd__nand2_1
X_08093_ _02393_ _02319_ _02396_ VSS VSS VDD VDD _02397_ sky130_fd_sc_hd__o21ai_4
X_08094_ _02325_ _02397_ VSS VSS VDD VDD _02398_ sky130_fd_sc_hd__xor2_1
X_08095_ _02387_ _02392_ _02398_ VSS VSS VDD VDD _02399_ sky130_fd_sc_hd__nand3_1
X_08096_ _02390_ _02386_ VSS VSS VDD VDD _02400_ sky130_fd_sc_hd__nand2_1
X_08097_ _02385_ _02391_ VSS VSS VDD VDD _02401_ sky130_fd_sc_hd__nand2_1
X_08098_ _02323_ _02397_ VSS VSS VDD VDD _02402_ sky130_fd_sc_hd__xor2_2
X_08099_ _02400_ _02401_ _02402_ VSS VSS VDD VDD _02403_ sky130_fd_sc_hd__nand3_1
X_08100_ _02399_ _02403_ VSS VSS VDD VDD _02404_ sky130_fd_sc_hd__nand2_1
X_08101_ _02328_ _02331_ _02330_ VSS VSS VDD VDD _02405_ sky130_fd_sc_hd__a21boi_1
X_08102_ _02404_ _02405_ VSS VSS VDD VDD _02406_ sky130_fd_sc_hd__nand2_1
X_08103_ _02400_ _02401_ _02398_ VSS VSS VDD VDD _02407_ sky130_fd_sc_hd__nand3_1
X_08104_ _02387_ _02392_ _02402_ VSS VSS VDD VDD _02408_ sky130_fd_sc_hd__nand3_1
X_08105_ _02407_ _02408_ VSS VSS VDD VDD _02409_ sky130_fd_sc_hd__nand2_1
X_08106_ _02336_ _02330_ VSS VSS VDD VDD _02410_ sky130_fd_sc_hd__nand2_1
X_08107_ _02409_ _02410_ VSS VSS VDD VDD _02411_ sky130_fd_sc_hd__nand2_1
X_08108_ _02326_ _02318_ VSS VSS VDD VDD _02412_ sky130_fd_sc_hd__nand2_1
X_08109_ _02412_ VSS VSS VDD VDD _02413_ sky130_fd_sc_hd__inv_2
X_08110_ _02344_ _02413_ VSS VSS VDD VDD _02414_ sky130_fd_sc_hd__nor2_2
X_08111_ _02414_ VSS VSS VDD VDD _02415_ sky130_fd_sc_hd__inv_2
X_08112_ _02413_ _02344_ VSS VSS VDD VDD _02416_ sky130_fd_sc_hd__nand2_1
X_08113_ _02415_ _02416_ VSS VSS VDD VDD _02417_ sky130_fd_sc_hd__nand2_1
X_08114_ _02417_ VSS VSS VDD VDD _02418_ sky130_fd_sc_hd__inv_1
X_08115_ _02406_ _02411_ _02418_ VSS VSS VDD VDD _02419_ sky130_fd_sc_hd__nand3_1
X_08116_ _02409_ _02405_ VSS VSS VDD VDD _02420_ sky130_fd_sc_hd__nand2_1
X_08117_ _02404_ _02410_ VSS VSS VDD VDD _02421_ sky130_fd_sc_hd__nand2_1
X_08118_ _02420_ _02421_ _02417_ VSS VSS VDD VDD _02422_ sky130_fd_sc_hd__nand3_1
X_08119_ _02419_ _02422_ VSS VSS VDD VDD _02423_ sky130_fd_sc_hd__nand2_1
X_08120_ _02347_ _02341_ _02335_ VSS VSS VDD VDD _02424_ sky130_fd_sc_hd__a21boi_1
X_08121_ _02423_ _02424_ VSS VSS VDD VDD _02425_ sky130_fd_sc_hd__nand2_1
X_08122_ _02420_ _02421_ _02418_ VSS VSS VDD VDD _02426_ sky130_fd_sc_hd__nand3_1
X_08123_ _02406_ _02411_ _02417_ VSS VSS VDD VDD _02427_ sky130_fd_sc_hd__nand3_1
X_08124_ _02426_ _02427_ VSS VSS VDD VDD _02428_ sky130_fd_sc_hd__nand2_1
X_08125_ _02348_ _02335_ VSS VSS VDD VDD _02429_ sky130_fd_sc_hd__nand2_1
X_08126_ _02428_ _02429_ VSS VSS VDD VDD _02430_ sky130_fd_sc_hd__nand2_1
X_08127_ _02343_ VSS VSS VDD VDD _02431_ sky130_fd_sc_hd__inv_1
X_08128_ _02425_ _02430_ _02431_ VSS VSS VDD VDD _02432_ sky130_fd_sc_hd__nand3_1
X_08129_ _02428_ _02424_ VSS VSS VDD VDD _02433_ sky130_fd_sc_hd__nand2_1
X_08130_ _02423_ _02429_ VSS VSS VDD VDD _02434_ sky130_fd_sc_hd__nand2_1
X_08131_ _02433_ _02434_ _02343_ VSS VSS VDD VDD _02435_ sky130_fd_sc_hd__nand3_1
X_08132_ _02432_ _02435_ VSS VSS VDD VDD _02436_ sky130_fd_sc_hd__nand2_1
X_08133_ _02362_ _02365_ _02364_ VSS VSS VDD VDD _02437_ sky130_fd_sc_hd__a21boi_1
X_08134_ _02436_ _02437_ VSS VSS VDD VDD _02438_ sky130_fd_sc_hd__nand2_1
X_08135_ _02433_ _02434_ _02431_ VSS VSS VDD VDD _02439_ sky130_fd_sc_hd__nand3_1
X_08136_ _02425_ _02430_ _02343_ VSS VSS VDD VDD _02440_ sky130_fd_sc_hd__nand3_1
X_08137_ _02439_ _02440_ VSS VSS VDD VDD _02441_ sky130_fd_sc_hd__nand2_1
X_08138_ _02353_ _02357_ VSS VSS VDD VDD _02442_ sky130_fd_sc_hd__nor2_1
X_08139_ _02361_ _02442_ _02364_ VSS VSS VDD VDD _02443_ sky130_fd_sc_hd__o21ai_1
X_08140_ _02441_ _02443_ VSS VSS VDD VDD _02444_ sky130_fd_sc_hd__nand2_1
X_08141_ _02438_ _02444_ VSS VSS VDD VDD _02445_ sky130_fd_sc_hd__nand2_1
X_08142_ _02373_ _02445_ VSS VSS VDD VDD _02446_ sky130_fd_sc_hd__nor2_1
X_08143_ _02297_ _02446_ VSS VSS VDD VDD _02447_ sky130_fd_sc_hd__nand2_2
X_08144_ _02371_ _02445_ _02444_ VSS VSS VDD VDD _02448_ sky130_fd_sc_hd__o21a_1
X_08145_ _02447_ _02448_ VSS VSS VDD VDD _02449_ sky130_fd_sc_hd__nand2_2
X_08146_ _02432_ _02430_ VSS VSS VDD VDD _02450_ sky130_fd_sc_hd__nand2_1
X_08147_ _02450_ VSS VSS VDD VDD _02451_ sky130_fd_sc_hd__inv_2
X_08148_ wrapped_design.a1_skew\[4\] _01924_ VSS VSS VDD VDD
+ _02452_ sky130_fd_sc_hd__nor2_1
X_08149_ wrapped_design.b00_down\[6\] wrapped_design.a1_skew\[5\]
+ VSS VSS VDD VDD _02453_ sky130_fd_sc_hd__nand2_1
X_08150_ _02453_ VSS VSS VDD VDD _02454_ sky130_fd_sc_hd__inv_1
X_08151_ _02452_ _02454_ VSS VSS VDD VDD _02455_ sky130_fd_sc_hd__nand2_1
X_08152_ _00675_ wrapped_design.b00_down\[7\] VSS VSS VDD
+ VDD _02456_ sky130_fd_sc_hd__nand2_1
X_08153_ _02456_ _02453_ VSS VSS VDD VDD _02457_ sky130_fd_sc_hd__nand2_1
X_08154_ _02455_ _02457_ VSS VSS VDD VDD _02458_ sky130_fd_sc_hd__nand2_1
X_08155_ wrapped_design.b00_down\[5\] wrapped_design.a1_skew\[6\]
+ VSS VSS VDD VDD _02459_ sky130_fd_sc_hd__nand2_1
X_08156_ _02459_ VSS VSS VDD VDD _02460_ sky130_fd_sc_hd__inv_1
X_08157_ _02458_ _02460_ VSS VSS VDD VDD _02461_ sky130_fd_sc_hd__nand2_1
X_08158_ _02455_ _02457_ _02459_ VSS VSS VDD VDD _02462_ sky130_fd_sc_hd__nand3_1
X_08159_ _02461_ _02462_ VSS VSS VDD VDD _02463_ sky130_fd_sc_hd__nand2_1
X_08160_ _02382_ _02379_ _02377_ VSS VSS VDD VDD _02464_ sky130_fd_sc_hd__a21boi_1
X_08161_ _02463_ _02464_ VSS VSS VDD VDD _02465_ sky130_fd_sc_hd__nand2_1
X_08162_ _02458_ _02459_ VSS VSS VDD VDD _02466_ sky130_fd_sc_hd__nand2_1
X_08163_ _02455_ _02457_ _02460_ VSS VSS VDD VDD _02467_ sky130_fd_sc_hd__nand3_1
X_08164_ _02466_ _02467_ VSS VSS VDD VDD _02468_ sky130_fd_sc_hd__nand2_1
X_08165_ _02389_ _02377_ VSS VSS VDD VDD _02469_ sky130_fd_sc_hd__nand2_1
X_08166_ _02468_ _02469_ VSS VSS VDD VDD _02470_ sky130_fd_sc_hd__nand2_1
X_08167_ _02394_ VSS VSS VDD VDD _02471_ sky130_fd_sc_hd__inv_2
X_08168_ _02471_ wrapped_design.b00_down\[4\] VSS VSS VDD
+ VDD _02472_ sky130_fd_sc_hd__nand2_2
X_08169_ _02394_ _02393_ VSS VSS VDD VDD _02473_ sky130_fd_sc_hd__nand2_1
X_08170_ _02472_ _02473_ VSS VSS VDD VDD _02474_ sky130_fd_sc_hd__nand2_1
X_08171_ _02474_ _02323_ VSS VSS VDD VDD _02475_ sky130_fd_sc_hd__nand2_1
X_08172_ _02472_ _02325_ _02473_ VSS VSS VDD VDD _02476_ sky130_fd_sc_hd__nand3_2
X_08173_ _02475_ _02476_ VSS VSS VDD VDD _02477_ sky130_fd_sc_hd__nand2_4
X_08174_ _02477_ VSS VSS VDD VDD _02478_ sky130_fd_sc_hd__inv_4
X_08175_ _02465_ _02470_ _02478_ VSS VSS VDD VDD _02479_ sky130_fd_sc_hd__nand3_1
X_08176_ _02468_ _02464_ VSS VSS VDD VDD _02480_ sky130_fd_sc_hd__nand2_1
X_08177_ _02463_ _02469_ VSS VSS VDD VDD _02481_ sky130_fd_sc_hd__nand2_1
X_08178_ _02480_ _02481_ _02477_ VSS VSS VDD VDD _02482_ sky130_fd_sc_hd__nand3_1
X_08179_ _02479_ _02482_ VSS VSS VDD VDD _02483_ sky130_fd_sc_hd__nand2_1
X_08180_ _02402_ _02400_ _02401_ VSS VSS VDD VDD _02484_ sky130_fd_sc_hd__a21boi_1
X_08181_ _02483_ _02484_ VSS VSS VDD VDD _02485_ sky130_fd_sc_hd__nand2_1
X_08182_ _02480_ _02481_ _02478_ VSS VSS VDD VDD _02486_ sky130_fd_sc_hd__nand3_1
X_08183_ _02465_ _02470_ _02477_ VSS VSS VDD VDD _02487_ sky130_fd_sc_hd__nand3_1
X_08184_ _02486_ _02487_ VSS VSS VDD VDD _02488_ sky130_fd_sc_hd__nand2_1
X_08185_ _02403_ _02401_ VSS VSS VDD VDD _02489_ sky130_fd_sc_hd__nand2_1
X_08186_ _02488_ _02489_ VSS VSS VDD VDD _02490_ sky130_fd_sc_hd__nand2_1
X_08187_ _02394_ _02395_ VSS VSS VDD VDD _02491_ sky130_fd_sc_hd__nor2_1
X_08188_ _02396_ _02325_ _02491_ VSS VSS VDD VDD _02492_ sky130_fd_sc_hd__a21oi_1
X_08189_ _02344_ _02492_ VSS VSS VDD VDD _02493_ sky130_fd_sc_hd__nor2_2
X_08190_ _02493_ VSS VSS VDD VDD _02494_ sky130_fd_sc_hd__inv_1
X_08191_ _02492_ _02344_ VSS VSS VDD VDD _02495_ sky130_fd_sc_hd__nand2_1
X_08192_ _02494_ _02495_ VSS VSS VDD VDD _02496_ sky130_fd_sc_hd__nand2_1
X_08193_ _02496_ VSS VSS VDD VDD _02497_ sky130_fd_sc_hd__inv_2
X_08194_ _02485_ _02490_ _02497_ VSS VSS VDD VDD _02498_ sky130_fd_sc_hd__nand3_1
X_08195_ _02488_ _02484_ VSS VSS VDD VDD _02499_ sky130_fd_sc_hd__nand2_1
X_08196_ _02483_ _02489_ VSS VSS VDD VDD _02500_ sky130_fd_sc_hd__nand2_1
X_08197_ _02499_ _02500_ _02496_ VSS VSS VDD VDD _02501_ sky130_fd_sc_hd__nand3_1
X_08198_ _02498_ _02501_ VSS VSS VDD VDD _02502_ sky130_fd_sc_hd__nand2_1
X_08199_ _02418_ _02406_ _02411_ VSS VSS VDD VDD _02503_ sky130_fd_sc_hd__a21boi_2
X_08200_ _02502_ _02503_ VSS VSS VDD VDD _02504_ sky130_fd_sc_hd__nand2_1
X_08201_ _02499_ _02500_ _02497_ VSS VSS VDD VDD _02506_ sky130_fd_sc_hd__nand3_2
X_08202_ _02485_ _02490_ _02496_ VSS VSS VDD VDD _02507_ sky130_fd_sc_hd__nand3_1
X_08203_ _02506_ _02507_ VSS VSS VDD VDD _02508_ sky130_fd_sc_hd__nand2_1
X_08204_ _02419_ _02411_ VSS VSS VDD VDD _02509_ sky130_fd_sc_hd__nand2_1
X_08205_ _02508_ _02509_ VSS VSS VDD VDD _02510_ sky130_fd_sc_hd__nand2_1
X_08206_ _02504_ _02510_ _02414_ VSS VSS VDD VDD _02511_ sky130_fd_sc_hd__nand3_1
X_08207_ _02508_ _02503_ VSS VSS VDD VDD _02512_ sky130_fd_sc_hd__nand2_1
X_08208_ _02502_ _02509_ VSS VSS VDD VDD _02513_ sky130_fd_sc_hd__nand2_1
X_08209_ _02512_ _02513_ _02415_ VSS VSS VDD VDD _02514_ sky130_fd_sc_hd__nand3_1
X_08210_ _02511_ _02514_ VSS VSS VDD VDD _02515_ sky130_fd_sc_hd__nand2_1
X_08211_ _02451_ _02515_ VSS VSS VDD VDD _02517_ sky130_fd_sc_hd__nand2_1
X_08212_ _02512_ _02513_ _02414_ VSS VSS VDD VDD _02518_ sky130_fd_sc_hd__nand3_1
X_08213_ _02504_ _02510_ _02415_ VSS VSS VDD VDD _02519_ sky130_fd_sc_hd__nand3_1
X_08214_ _02518_ _02519_ VSS VSS VDD VDD _02520_ sky130_fd_sc_hd__nand2_1
X_08215_ _02520_ _02450_ VSS VSS VDD VDD _02521_ sky130_fd_sc_hd__nand2_1
X_08216_ _02517_ _02521_ VSS VSS VDD VDD _02522_ sky130_fd_sc_hd__nand2_1
X_08217_ wrapped_design.a1_skew\[5\] _01924_ VSS VSS VDD VDD
+ _02523_ sky130_fd_sc_hd__nor2_1
X_08218_ wrapped_design.b00_down\[6\] wrapped_design.a1_skew\[6\]
+ VSS VSS VDD VDD _02524_ sky130_fd_sc_hd__nand2_1
X_08219_ _02524_ VSS VSS VDD VDD _02525_ sky130_fd_sc_hd__inv_1
X_08220_ _02523_ _02525_ VSS VSS VDD VDD _02526_ sky130_fd_sc_hd__nand2_1
X_08221_ _00672_ wrapped_design.b00_down\[7\] VSS VSS VDD
+ VDD _02528_ sky130_fd_sc_hd__nand2_1
X_08222_ _02528_ _02524_ VSS VSS VDD VDD _02529_ sky130_fd_sc_hd__nand2_1
X_08223_ _02526_ _02529_ VSS VSS VDD VDD _02530_ sky130_fd_sc_hd__nand2_1
X_08224_ wrapped_design.a1_skew\[7\] wrapped_design.b00_down\[5\]
+ VSS VSS VDD VDD _02531_ sky130_fd_sc_hd__nand2_1
X_08225_ _02531_ VSS VSS VDD VDD _02532_ sky130_fd_sc_hd__inv_2
X_08226_ _02530_ _02532_ VSS VSS VDD VDD _02533_ sky130_fd_sc_hd__nand2_1
X_08227_ _02526_ _02529_ _02531_ VSS VSS VDD VDD _02534_ sky130_fd_sc_hd__nand3_1
X_08228_ _02533_ _02534_ VSS VSS VDD VDD _02535_ sky130_fd_sc_hd__nand2_1
X_08229_ _02460_ _02457_ _02455_ VSS VSS VDD VDD _02536_ sky130_fd_sc_hd__a21boi_1
X_08230_ _02535_ _02536_ VSS VSS VDD VDD _02537_ sky130_fd_sc_hd__nand2_1
X_08231_ _02530_ _02531_ VSS VSS VDD VDD _02539_ sky130_fd_sc_hd__nand2_1
X_08232_ _02526_ _02529_ _02532_ VSS VSS VDD VDD _02540_ sky130_fd_sc_hd__nand3_1
X_08233_ _02539_ _02540_ VSS VSS VDD VDD _02541_ sky130_fd_sc_hd__nand2_1
X_08234_ _02467_ _02455_ VSS VSS VDD VDD _02542_ sky130_fd_sc_hd__nand2_1
X_08235_ _02541_ _02542_ VSS VSS VDD VDD _02543_ sky130_fd_sc_hd__nand2_1
X_08236_ _02537_ _02543_ _02478_ VSS VSS VDD VDD _02544_ sky130_fd_sc_hd__nand3_1
X_08237_ _02541_ _02536_ VSS VSS VDD VDD _02545_ sky130_fd_sc_hd__nand2_1
X_08238_ _02535_ _02542_ VSS VSS VDD VDD _02546_ sky130_fd_sc_hd__nand2_1
X_08239_ _02545_ _02546_ _02477_ VSS VSS VDD VDD _02547_ sky130_fd_sc_hd__nand3_1
X_08240_ _02544_ _02547_ VSS VSS VDD VDD _02548_ sky130_fd_sc_hd__nand2_1
X_08241_ _02478_ _02480_ _02481_ VSS VSS VDD VDD _02550_ sky130_fd_sc_hd__a21boi_2
X_08242_ _02548_ _02550_ VSS VSS VDD VDD _02551_ sky130_fd_sc_hd__nand2_1
X_08243_ _02545_ _02546_ _02478_ VSS VSS VDD VDD _02552_ sky130_fd_sc_hd__nand3_1
X_08244_ _02537_ _02543_ _02477_ VSS VSS VDD VDD _02553_ sky130_fd_sc_hd__nand3_1
X_08245_ _02552_ _02553_ VSS VSS VDD VDD _02554_ sky130_fd_sc_hd__nand2_1
X_08246_ _02486_ _02481_ VSS VSS VDD VDD _02555_ sky130_fd_sc_hd__nand2_1
X_08247_ _02554_ _02555_ VSS VSS VDD VDD _02556_ sky130_fd_sc_hd__nand2_1
X_08248_ _02476_ _02472_ VSS VSS VDD VDD _02557_ sky130_fd_sc_hd__nand2_1
X_08249_ _02013_ _02557_ VSS VSS VDD VDD _02558_ sky130_fd_sc_hd__nor2_1
X_08250_ _02476_ _02472_ _02344_ VSS VSS VDD VDD _02559_ sky130_fd_sc_hd__a21oi_4
X_08251_ _02558_ _02559_ VSS VSS VDD VDD _02561_ sky130_fd_sc_hd__nor2_4
X_08252_ _02551_ _02556_ _02561_ VSS VSS VDD VDD _02562_ sky130_fd_sc_hd__nand3_1
X_08253_ _02554_ _02550_ VSS VSS VDD VDD _02563_ sky130_fd_sc_hd__nand2_1
X_08254_ _02548_ _02555_ VSS VSS VDD VDD _02564_ sky130_fd_sc_hd__nand2_1
X_08255_ _02561_ VSS VSS VDD VDD _02565_ sky130_fd_sc_hd__inv_2
X_08256_ _02563_ _02564_ _02565_ VSS VSS VDD VDD _02566_ sky130_fd_sc_hd__nand3_1
X_08257_ _02562_ _02566_ VSS VSS VDD VDD _02567_ sky130_fd_sc_hd__nand2_1
X_08258_ _02497_ _02499_ _02500_ VSS VSS VDD VDD _02568_ sky130_fd_sc_hd__a21boi_2
X_08259_ _02567_ _02568_ VSS VSS VDD VDD _02569_ sky130_fd_sc_hd__nand2_1
X_08260_ _02563_ _02564_ _02561_ VSS VSS VDD VDD _02570_ sky130_fd_sc_hd__nand3_1
X_08261_ _02551_ _02556_ _02565_ VSS VSS VDD VDD _02572_ sky130_fd_sc_hd__nand3_1
X_08262_ _02570_ _02572_ VSS VSS VDD VDD _02573_ sky130_fd_sc_hd__nand2_1
X_08263_ _02506_ _02500_ VSS VSS VDD VDD _02574_ sky130_fd_sc_hd__nand2_1
X_08264_ _02573_ _02574_ VSS VSS VDD VDD _02575_ sky130_fd_sc_hd__nand2_1
X_08265_ _02569_ _02575_ _02493_ VSS VSS VDD VDD _02576_ sky130_fd_sc_hd__nand3_1
X_08266_ _02573_ _02568_ VSS VSS VDD VDD _02577_ sky130_fd_sc_hd__nand2_1
X_08267_ _02567_ _02574_ VSS VSS VDD VDD _02578_ sky130_fd_sc_hd__nand2_1
X_08268_ _02577_ _02578_ _02494_ VSS VSS VDD VDD _02579_ sky130_fd_sc_hd__nand3_1
X_08269_ _02576_ _02579_ VSS VSS VDD VDD _02580_ sky130_fd_sc_hd__nand2_1
X_08270_ _02414_ _02512_ _02513_ VSS VSS VDD VDD _02581_ sky130_fd_sc_hd__a21boi_1
X_08271_ _02580_ _02581_ VSS VSS VDD VDD _02583_ sky130_fd_sc_hd__nand2_1
X_08272_ _02577_ _02578_ _02493_ VSS VSS VDD VDD _02584_ sky130_fd_sc_hd__nand3_1
X_08273_ _02569_ _02575_ _02494_ VSS VSS VDD VDD _02585_ sky130_fd_sc_hd__nand3_1
X_08274_ _02584_ _02585_ VSS VSS VDD VDD _02586_ sky130_fd_sc_hd__nand2_1
X_08275_ _02518_ _02513_ VSS VSS VDD VDD _02587_ sky130_fd_sc_hd__nand2_1
X_08276_ _02586_ _02587_ VSS VSS VDD VDD _02588_ sky130_fd_sc_hd__nand2_1
X_08277_ _02583_ _02588_ VSS VSS VDD VDD _02589_ sky130_fd_sc_hd__nand2_2
X_08278_ _02522_ _02589_ VSS VSS VDD VDD _02590_ sky130_fd_sc_hd__nand2_1
X_08279_ _02590_ VSS VSS VDD VDD _02591_ sky130_fd_sc_hd__inv_1
X_08280_ _02449_ _02591_ VSS VSS VDD VDD _02592_ sky130_fd_sc_hd__nand2_1
X_08281_ _02520_ _02451_ VSS VSS VDD VDD _02594_ sky130_fd_sc_hd__nor2_1
X_08282_ _02589_ _02594_ VSS VSS VDD VDD _02595_ sky130_fd_sc_hd__nand2_1
X_08283_ _02580_ _02587_ VSS VSS VDD VDD _02596_ sky130_fd_sc_hd__nand2_1
X_08284_ _02595_ _02596_ VSS VSS VDD VDD _02597_ sky130_fd_sc_hd__nand2_1
X_08285_ _02597_ VSS VSS VDD VDD _02598_ sky130_fd_sc_hd__inv_1
X_08286_ _02592_ _02598_ VSS VSS VDD VDD _02599_ sky130_fd_sc_hd__nand2_1
X_08287_ wrapped_design.a1_skew\[6\] _01924_ VSS VSS VDD VDD
+ _02600_ sky130_fd_sc_hd__nor2_1
X_08288_ wrapped_design.a1_skew\[7\] wrapped_design.b00_down\[6\]
+ VSS VSS VDD VDD _02601_ sky130_fd_sc_hd__nand2_1
X_08289_ _02601_ VSS VSS VDD VDD _02602_ sky130_fd_sc_hd__inv_1
X_08290_ _02600_ _02602_ VSS VSS VDD VDD _02603_ sky130_fd_sc_hd__nand2_1
X_08291_ _00668_ wrapped_design.b00_down\[7\] VSS VSS VDD
+ VDD _02605_ sky130_fd_sc_hd__nand2_1
X_08292_ _02605_ _02601_ VSS VSS VDD VDD _02606_ sky130_fd_sc_hd__nand2_1
X_08293_ _02603_ _02606_ VSS VSS VDD VDD _02607_ sky130_fd_sc_hd__nand2_1
X_08294_ _02607_ _02531_ VSS VSS VDD VDD _02608_ sky130_fd_sc_hd__nand2_1
X_08295_ _02603_ _02606_ _02532_ VSS VSS VDD VDD _02609_ sky130_fd_sc_hd__nand3_1
X_08296_ _02608_ _02609_ VSS VSS VDD VDD _02610_ sky130_fd_sc_hd__nand2_1
X_08297_ _02532_ _02529_ _02526_ VSS VSS VDD VDD _02611_ sky130_fd_sc_hd__a21boi_0
X_08298_ _02610_ _02611_ VSS VSS VDD VDD _02612_ sky130_fd_sc_hd__nand2_1
X_08299_ _02607_ _02532_ VSS VSS VDD VDD _02613_ sky130_fd_sc_hd__nand2_1
X_08300_ _02603_ _02606_ _02531_ VSS VSS VDD VDD _02614_ sky130_fd_sc_hd__nand3_1
X_08301_ _02613_ _02614_ VSS VSS VDD VDD _02616_ sky130_fd_sc_hd__nand2_1
X_08302_ _02540_ _02526_ VSS VSS VDD VDD _02617_ sky130_fd_sc_hd__nand2_1
X_08303_ _02616_ _02617_ VSS VSS VDD VDD _02618_ sky130_fd_sc_hd__nand2_1
X_08304_ _02612_ _02618_ _02478_ VSS VSS VDD VDD _02619_ sky130_fd_sc_hd__nand3_1
X_08305_ _02616_ _02611_ VSS VSS VDD VDD _02620_ sky130_fd_sc_hd__nand2_1
X_08306_ _02610_ _02617_ VSS VSS VDD VDD _02621_ sky130_fd_sc_hd__nand2_1
X_08307_ _02620_ _02621_ _02477_ VSS VSS VDD VDD _02622_ sky130_fd_sc_hd__nand3_1
X_08308_ _02619_ _02622_ VSS VSS VDD VDD _02623_ sky130_fd_sc_hd__nand2_1
X_08309_ _02478_ _02545_ _02546_ VSS VSS VDD VDD _02624_ sky130_fd_sc_hd__a21boi_1
X_08310_ _02623_ _02624_ VSS VSS VDD VDD _02625_ sky130_fd_sc_hd__nand2_1
X_08311_ _02620_ _02621_ _02478_ VSS VSS VDD VDD _02627_ sky130_fd_sc_hd__nand3_1
X_08312_ _02612_ _02618_ _02477_ VSS VSS VDD VDD _02628_ sky130_fd_sc_hd__nand3_1
X_08313_ _02627_ _02628_ VSS VSS VDD VDD _02629_ sky130_fd_sc_hd__nand2_1
X_08314_ _02552_ _02546_ VSS VSS VDD VDD _02630_ sky130_fd_sc_hd__nand2_1
X_08315_ _02629_ _02630_ VSS VSS VDD VDD _02631_ sky130_fd_sc_hd__nand2_1
X_08316_ _02625_ _02631_ _02561_ VSS VSS VDD VDD _02632_ sky130_fd_sc_hd__nand3_1
X_08317_ _02629_ _02624_ VSS VSS VDD VDD _02633_ sky130_fd_sc_hd__nand2_1
X_08318_ _02623_ _02630_ VSS VSS VDD VDD _02634_ sky130_fd_sc_hd__nand2_1
X_08319_ _02633_ _02634_ _02565_ VSS VSS VDD VDD _02635_ sky130_fd_sc_hd__nand3_1
X_08320_ _02632_ _02635_ VSS VSS VDD VDD _02636_ sky130_fd_sc_hd__nand2_1
X_08321_ _02561_ _02563_ _02564_ VSS VSS VDD VDD _02638_ sky130_fd_sc_hd__a21boi_1
X_08322_ _02636_ _02638_ VSS VSS VDD VDD _02639_ sky130_fd_sc_hd__nand2_1
X_08323_ _02633_ _02634_ _02561_ VSS VSS VDD VDD _02640_ sky130_fd_sc_hd__nand3_1
X_08324_ _02625_ _02631_ _02565_ VSS VSS VDD VDD _02641_ sky130_fd_sc_hd__nand3_1
X_08325_ _02640_ _02641_ VSS VSS VDD VDD _02642_ sky130_fd_sc_hd__nand2_1
X_08326_ _02570_ _02564_ VSS VSS VDD VDD _02643_ sky130_fd_sc_hd__nand2_1
X_08327_ _02642_ _02643_ VSS VSS VDD VDD _02644_ sky130_fd_sc_hd__nand2_1
X_08328_ _02639_ _02644_ _02559_ VSS VSS VDD VDD _02645_ sky130_fd_sc_hd__nand3_1
X_08329_ _02642_ _02638_ VSS VSS VDD VDD _02646_ sky130_fd_sc_hd__nand2_1
X_08330_ _02636_ _02643_ VSS VSS VDD VDD _02647_ sky130_fd_sc_hd__nand2_1
X_08331_ _02559_ VSS VSS VDD VDD _02649_ sky130_fd_sc_hd__inv_1
X_08332_ _02646_ _02647_ _02649_ VSS VSS VDD VDD _02650_ sky130_fd_sc_hd__nand3_1
X_08333_ _02645_ _02650_ VSS VSS VDD VDD _02651_ sky130_fd_sc_hd__nand2_1
X_08334_ _02493_ _02577_ _02578_ VSS VSS VDD VDD _02652_ sky130_fd_sc_hd__a21boi_1
X_08335_ _02651_ _02652_ VSS VSS VDD VDD _02653_ sky130_fd_sc_hd__nand2_1
X_08336_ _02646_ _02647_ _02559_ VSS VSS VDD VDD _02654_ sky130_fd_sc_hd__nand3_1
X_08337_ _02639_ _02644_ _02649_ VSS VSS VDD VDD _02655_ sky130_fd_sc_hd__nand3_1
X_08338_ _02654_ _02655_ VSS VSS VDD VDD _02656_ sky130_fd_sc_hd__nand2_1
X_08339_ _02584_ _02578_ VSS VSS VDD VDD _02657_ sky130_fd_sc_hd__nand2_1
X_08340_ _02656_ _02657_ VSS VSS VDD VDD _02658_ sky130_fd_sc_hd__nand2_1
X_08341_ _02653_ _02658_ VSS VSS VDD VDD _02660_ sky130_fd_sc_hd__nand2_2
X_08342_ _02599_ _02660_ VSS VSS VDD VDD _02661_ sky130_fd_sc_hd__nand2_1
X_08343_ _02656_ _02652_ VSS VSS VDD VDD _02662_ sky130_fd_sc_hd__nand2_1
X_08344_ _02651_ _02657_ VSS VSS VDD VDD _02663_ sky130_fd_sc_hd__nand2_1
X_08345_ _02662_ _02663_ VSS VSS VDD VDD _02664_ sky130_fd_sc_hd__nand2_1
X_08346_ _02592_ _02664_ _02598_ VSS VSS VDD VDD _02665_ sky130_fd_sc_hd__nand3_1
X_08347_ _02661_ net89 _02665_ VSS VSS VDD VDD _02666_ sky130_fd_sc_hd__nand3_1
X_08348_ _02599_ _02664_ VSS VSS VDD VDD _02667_ sky130_fd_sc_hd__nand2_1
X_08349_ net89 VSS VSS VDD VDD _02668_ sky130_fd_sc_hd__inv_1
X_08350_ _02592_ _02660_ _02598_ VSS VSS VDD VDD _02669_ sky130_fd_sc_hd__nand3_1
X_08351_ _02667_ _02668_ _02669_ VSS VSS VDD VDD _02671_ sky130_fd_sc_hd__nand3_1
X_08352_ _02666_ _02671_ VSS VSS VDD VDD _02672_ sky130_fd_sc_hd__nand2_1
X_08353_ _02284_ _02283_ _02281_ VSS VSS VDD VDD _02673_ sky130_fd_sc_hd__nand3_1
X_08354_ _02273_ _02673_ VSS VSS VDD VDD _02674_ sky130_fd_sc_hd__nand2_1
X_08355_ _02674_ _02293_ VSS VSS VDD VDD _02675_ sky130_fd_sc_hd__nand2_1
X_08356_ _02292_ _02295_ VSS VSS VDD VDD _02676_ sky130_fd_sc_hd__nand2_1
X_08357_ _02676_ _02373_ VSS VSS VDD VDD _02677_ sky130_fd_sc_hd__nor2_1
X_08358_ _02675_ _02677_ VSS VSS VDD VDD _02678_ sky130_fd_sc_hd__nand2_2
X_08359_ _02371_ _02292_ VSS VSS VDD VDD _02679_ sky130_fd_sc_hd__nand2_1
X_08360_ _02679_ _02372_ VSS VSS VDD VDD _02680_ sky130_fd_sc_hd__nand2_1
X_08361_ _02678_ _02680_ VSS VSS VDD VDD _02682_ sky130_fd_sc_hd__nand2_1
X_08362_ _02682_ _02445_ VSS VSS VDD VDD _02683_ sky130_fd_sc_hd__nand2_1
X_08363_ _02441_ _02437_ VSS VSS VDD VDD _02684_ sky130_fd_sc_hd__nand2_1
X_08364_ _02436_ _02443_ VSS VSS VDD VDD _02685_ sky130_fd_sc_hd__nand2_1
X_08365_ _02684_ _02685_ VSS VSS VDD VDD _02686_ sky130_fd_sc_hd__nand2_1
X_08366_ _02678_ _02686_ _02680_ VSS VSS VDD VDD _02687_ sky130_fd_sc_hd__nand3_1
X_08367_ _02683_ _02687_ VSS VSS VDD VDD _02688_ sky130_fd_sc_hd__nand2_1
X_08368_ _02688_ net86 VSS VSS VDD VDD _02689_ sky130_fd_sc_hd__nand2_1
X_08369_ net86 VSS VSS VDD VDD _02690_ sky130_fd_sc_hd__inv_1
X_08370_ _02683_ _02687_ _02690_ VSS VSS VDD VDD _02691_ sky130_fd_sc_hd__nand3_1
X_08371_ _02689_ _02691_ VSS VSS VDD VDD _02693_ sky130_fd_sc_hd__nand2_1
X_08372_ _02449_ _02522_ VSS VSS VDD VDD _02694_ sky130_fd_sc_hd__nand2_1
X_08373_ _02522_ VSS VSS VDD VDD _02695_ sky130_fd_sc_hd__inv_1
X_08374_ _02447_ _02448_ _02695_ VSS VSS VDD VDD _02696_ sky130_fd_sc_hd__nand3_1
X_08375_ _02694_ _02696_ VSS VSS VDD VDD _02697_ sky130_fd_sc_hd__nand2_1
X_08376_ net87 VSS VSS VDD VDD _02698_ sky130_fd_sc_hd__inv_1
X_08377_ _02697_ _02698_ VSS VSS VDD VDD _02699_ sky130_fd_sc_hd__nand2_1
X_08378_ _02694_ net87 _02696_ VSS VSS VDD VDD _02700_ sky130_fd_sc_hd__nand3_1
X_08379_ _02699_ _02700_ VSS VSS VDD VDD _02701_ sky130_fd_sc_hd__nand2_1
X_08380_ _02693_ _02701_ VSS VSS VDD VDD _02702_ sky130_fd_sc_hd__nor2_1
X_08381_ _02515_ _02450_ VSS VSS VDD VDD _02704_ sky130_fd_sc_hd__nand2_1
X_08382_ _02704_ _02444_ VSS VSS VDD VDD _02705_ sky130_fd_sc_hd__nand2_1
X_08383_ _02451_ _02520_ VSS VSS VDD VDD _02706_ sky130_fd_sc_hd__nand2_1
X_08384_ _02705_ _02706_ VSS VSS VDD VDD _02707_ sky130_fd_sc_hd__nand2_1
X_08385_ _02678_ _02707_ _02680_ VSS VSS VDD VDD _02708_ sky130_fd_sc_hd__nand3_1
X_08386_ _02522_ _02686_ VSS VSS VDD VDD _02709_ sky130_fd_sc_hd__nand2_1
X_08387_ _02709_ _02707_ VSS VSS VDD VDD _02710_ sky130_fd_sc_hd__nand2_1
X_08388_ _02708_ _02710_ VSS VSS VDD VDD _02711_ sky130_fd_sc_hd__nand2_1
X_08389_ _02711_ _02589_ VSS VSS VDD VDD _02712_ sky130_fd_sc_hd__nand2_1
X_08390_ _02589_ VSS VSS VDD VDD _02713_ sky130_fd_sc_hd__inv_1
X_08391_ _02708_ _02713_ _02710_ VSS VSS VDD VDD _02715_ sky130_fd_sc_hd__nand3_1
X_08392_ _02712_ _02715_ VSS VSS VDD VDD _02716_ sky130_fd_sc_hd__nand2_1
X_08393_ net88 VSS VSS VDD VDD _02717_ sky130_fd_sc_hd__inv_1
X_08394_ _02716_ _02717_ VSS VSS VDD VDD _02718_ sky130_fd_sc_hd__nand2_1
X_08395_ _02712_ net88 _02715_ VSS VSS VDD VDD _02719_ sky130_fd_sc_hd__nand3_1
X_08396_ _02718_ _02719_ VSS VSS VDD VDD _02720_ sky130_fd_sc_hd__nand2_1
X_08397_ _02297_ _02373_ VSS VSS VDD VDD _02721_ sky130_fd_sc_hd__nand2_1
X_08398_ _02373_ _02288_ _02296_ VSS VSS VDD VDD _02722_ sky130_fd_sc_hd__nand3b_1
X_08399_ _02721_ _02722_ VSS VSS VDD VDD _02723_ sky130_fd_sc_hd__nand2_1
X_08400_ net108 VSS VSS VDD VDD _02724_ sky130_fd_sc_hd__inv_1
X_08401_ _02723_ _02724_ VSS VSS VDD VDD _02726_ sky130_fd_sc_hd__nand2_1
X_08402_ _02721_ _02722_ net108 VSS VSS VDD VDD _02727_ sky130_fd_sc_hd__nand3_1
X_08403_ _02726_ _02727_ VSS VSS VDD VDD _02728_ sky130_fd_sc_hd__nand2_1
X_08404_ _02273_ _02286_ _02282_ VSS VSS VDD VDD _02729_ sky130_fd_sc_hd__nand3_1
X_08405_ _02273_ VSS VSS VDD VDD _02730_ sky130_fd_sc_hd__inv_1
X_08406_ _02730_ _02287_ VSS VSS VDD VDD _02731_ sky130_fd_sc_hd__nand2_1
X_08407_ _02729_ _02731_ VSS VSS VDD VDD _02732_ sky130_fd_sc_hd__nand2_1
X_08408_ _02732_ net106 VSS VSS VDD VDD _02733_ sky130_fd_sc_hd__nand2_1
X_08409_ _02252_ _02265_ _02269_ VSS VSS VDD VDD _02734_ sky130_fd_sc_hd__nand3_1
X_08410_ _02272_ _02734_ VSS VSS VDD VDD _02735_ sky130_fd_sc_hd__nand2_1
X_08411_ _02251_ VSS VSS VDD VDD _02737_ sky130_fd_sc_hd__inv_1
X_08412_ _02735_ _02737_ VSS VSS VDD VDD _02738_ sky130_fd_sc_hd__nand2_1
X_08413_ _02272_ _02251_ _02734_ VSS VSS VDD VDD _02739_ sky130_fd_sc_hd__nand3_1
X_08414_ _02738_ _02739_ VSS VSS VDD VDD _02740_ sky130_fd_sc_hd__nand2_1
X_08415_ _02740_ net105 VSS VSS VDD VDD _02741_ sky130_fd_sc_hd__nand2_1
X_08416_ net106 _02732_ VSS VSS VDD VDD _02742_ sky130_fd_sc_hd__nor2_1
X_08417_ _02733_ _02741_ _02742_ VSS VSS VDD VDD _02743_ sky130_fd_sc_hd__a21oi_1
X_08418_ _02675_ _02676_ VSS VSS VDD VDD _02744_ sky130_fd_sc_hd__nand2_1
X_08419_ _02674_ _02293_ _02160_ VSS VSS VDD VDD _02745_ sky130_fd_sc_hd__nand3_1
X_08420_ _02744_ _02745_ VSS VSS VDD VDD _02746_ sky130_fd_sc_hd__nand2_1
X_08421_ net107 VSS VSS VDD VDD _02748_ sky130_fd_sc_hd__inv_1
X_08422_ _02746_ _02748_ VSS VSS VDD VDD _02749_ sky130_fd_sc_hd__nand2_1
X_08423_ _02744_ net107 _02745_ VSS VSS VDD VDD _02750_ sky130_fd_sc_hd__nand3_1
X_08424_ _02749_ _02750_ VSS VSS VDD VDD _02751_ sky130_fd_sc_hd__nand2_2
X_08425_ _02728_ _02743_ _02751_ VSS VSS VDD VDD _02752_ sky130_fd_sc_hd__nand3_1
X_08426_ _02723_ net108 VSS VSS VDD VDD _02753_ sky130_fd_sc_hd__nand2_1
X_08427_ _02675_ _02160_ VSS VSS VDD VDD _02754_ sky130_fd_sc_hd__nand2_1
X_08428_ _02674_ _02293_ _02676_ VSS VSS VDD VDD _02755_ sky130_fd_sc_hd__nand3_1
X_08429_ _02754_ net107 _02755_ VSS VSS VDD VDD _02756_ sky130_fd_sc_hd__nand3_1
X_08430_ _02753_ _02756_ VSS VSS VDD VDD _02757_ sky130_fd_sc_hd__nand2_1
X_08431_ _02721_ _02724_ _02722_ VSS VSS VDD VDD _02759_ sky130_fd_sc_hd__nand3_1
X_08432_ _02757_ _02759_ VSS VSS VDD VDD _02760_ sky130_fd_sc_hd__nand2_1
X_08433_ _02752_ _02760_ VSS VSS VDD VDD _02761_ sky130_fd_sc_hd__nand2_1
X_08434_ _02672_ _02702_ _02720_ _02761_ VSS VSS VDD VDD _02762_
+ sky130_fd_sc_hd__nand4_1
X_08435_ _02667_ net89 _02669_ VSS VSS VDD VDD _02763_ sky130_fd_sc_hd__nand3_1
X_08436_ _02716_ net88 VSS VSS VDD VDD _02764_ sky130_fd_sc_hd__nand2_1
X_08437_ _02763_ _02764_ VSS VSS VDD VDD _02765_ sky130_fd_sc_hd__nand2_1
X_08438_ _02667_ _02669_ VSS VSS VDD VDD _02766_ sky130_fd_sc_hd__nand2_1
X_08439_ _02766_ _02668_ VSS VSS VDD VDD _02767_ sky130_fd_sc_hd__nand2_1
X_08440_ _02765_ _02767_ VSS VSS VDD VDD _02768_ sky130_fd_sc_hd__nand2_1
X_08441_ _02700_ _02689_ VSS VSS VDD VDD _02770_ sky130_fd_sc_hd__nand2_1
X_08442_ _02770_ _02699_ VSS VSS VDD VDD _02771_ sky130_fd_sc_hd__nand2_1
X_08443_ _02771_ _02672_ _02720_ VSS VSS VDD VDD _02772_ sky130_fd_sc_hd__nand3b_1
X_08444_ _02762_ _02768_ _02772_ VSS VSS VDD VDD _02773_ sky130_fd_sc_hd__nand3_1
X_08445_ _02609_ _02603_ VSS VSS VDD VDD _02774_ sky130_fd_sc_hd__nand2_1
X_08446_ _02532_ wrapped_design.b00_down\[6\] VSS VSS VDD
+ VDD _02775_ sky130_fd_sc_hd__nand2_1
X_08447_ wrapped_design.a1_skew\[7\] _01924_ _02601_ VSS VSS
+ VDD VDD _02776_ sky130_fd_sc_hd__o21ai_0
X_08448_ _02532_ _02776_ VSS VSS VDD VDD _02777_ sky130_fd_sc_hd__nor2_1
X_08449_ _02774_ _02775_ _02777_ VSS VSS VDD VDD _02778_ sky130_fd_sc_hd__a21oi_1
X_08450_ _02778_ VSS VSS VDD VDD _02779_ sky130_fd_sc_hd__inv_1
X_08451_ _02779_ _02477_ VSS VSS VDD VDD _02781_ sky130_fd_sc_hd__nand2_1
X_08452_ _02778_ _02478_ VSS VSS VDD VDD _02782_ sky130_fd_sc_hd__nand2_1
X_08453_ _02781_ _02782_ VSS VSS VDD VDD _02783_ sky130_fd_sc_hd__nand2_1
X_08454_ _02619_ _02618_ VSS VSS VDD VDD _02784_ sky130_fd_sc_hd__nand2_1
X_08455_ _02784_ VSS VSS VDD VDD _02785_ sky130_fd_sc_hd__inv_1
X_08456_ _02783_ _02785_ VSS VSS VDD VDD _02786_ sky130_fd_sc_hd__nand2_1
X_08457_ _02784_ _02781_ _02782_ VSS VSS VDD VDD _02787_ sky130_fd_sc_hd__nand3_1
X_08458_ _02786_ _02787_ VSS VSS VDD VDD _02788_ sky130_fd_sc_hd__nand2_1
X_08459_ _02788_ _02561_ VSS VSS VDD VDD _02789_ sky130_fd_sc_hd__nand2_1
X_08460_ _02786_ _02787_ _02565_ VSS VSS VDD VDD _02790_ sky130_fd_sc_hd__nand3_1
X_08461_ _02789_ _02790_ VSS VSS VDD VDD _02792_ sky130_fd_sc_hd__nand2_1
X_08462_ _02632_ _02631_ VSS VSS VDD VDD _02793_ sky130_fd_sc_hd__nand2_1
X_08463_ _02792_ _02793_ VSS VSS VDD VDD _02794_ sky130_fd_sc_hd__nand2_1
X_08464_ _02788_ _02565_ VSS VSS VDD VDD _02795_ sky130_fd_sc_hd__nand2_1
X_08465_ _02786_ _02787_ _02561_ VSS VSS VDD VDD _02796_ sky130_fd_sc_hd__nand3_1
X_08466_ _02795_ _02796_ VSS VSS VDD VDD _02797_ sky130_fd_sc_hd__nand2_1
X_08467_ _02793_ VSS VSS VDD VDD _02798_ sky130_fd_sc_hd__inv_1
X_08468_ _02797_ _02798_ VSS VSS VDD VDD _02799_ sky130_fd_sc_hd__nand2_1
X_08469_ _02794_ _02799_ VSS VSS VDD VDD _02800_ sky130_fd_sc_hd__nand2_1
X_08470_ _02800_ _02649_ VSS VSS VDD VDD _02801_ sky130_fd_sc_hd__nand2_1
X_08471_ _02794_ _02799_ _02559_ VSS VSS VDD VDD _02803_ sky130_fd_sc_hd__nand3_1
X_08472_ _02801_ _02803_ VSS VSS VDD VDD _02804_ sky130_fd_sc_hd__nand2_1
X_08473_ _02645_ _02644_ VSS VSS VDD VDD _02805_ sky130_fd_sc_hd__nand2_1
X_08474_ _02805_ VSS VSS VDD VDD _02806_ sky130_fd_sc_hd__inv_1
X_08475_ _02804_ _02806_ VSS VSS VDD VDD _02807_ sky130_fd_sc_hd__nand2_1
X_08476_ _02805_ _02801_ _02803_ VSS VSS VDD VDD _02808_ sky130_fd_sc_hd__nand3_1
X_08477_ _02807_ _02808_ VSS VSS VDD VDD _02809_ sky130_fd_sc_hd__nand2_2
X_08478_ _02660_ _02809_ _02590_ VSS VSS VDD VDD _02810_ sky130_fd_sc_hd__nor3_2
X_08479_ _02449_ _02810_ VSS VSS VDD VDD _02811_ sky130_fd_sc_hd__nand2_4
X_08480_ _02660_ _02809_ VSS VSS VDD VDD _02812_ sky130_fd_sc_hd__nor2_1
X_08481_ _02658_ _02808_ _02807_ VSS VSS VDD VDD _02814_ sky130_fd_sc_hd__a21boi_0
X_08482_ _02597_ _02812_ _02814_ VSS VSS VDD VDD _02815_ sky130_fd_sc_hd__a21oi_4
X_08483_ _02561_ _02781_ VSS VSS VDD VDD _02816_ sky130_fd_sc_hd__xor2_1
X_08484_ _02786_ _02561_ _02816_ _02787_ VSS VSS VDD VDD _02817_
+ sky130_fd_sc_hd__a22oi_1
X_08485_ _02817_ _02559_ VSS VSS VDD VDD _02818_ sky130_fd_sc_hd__nand2_1
X_08486_ _02559_ _02794_ _02818_ VSS VSS VDD VDD _02819_ sky130_fd_sc_hd__o21ai_0
X_08487_ _02817_ _02819_ VSS VSS VDD VDD _02820_ sky130_fd_sc_hd__xor2_1
X_08488_ _02820_ VSS VSS VDD VDD _02821_ sky130_fd_sc_hd__inv_1
X_08489_ _02811_ _02815_ _02821_ VSS VSS VDD VDD _02822_ sky130_fd_sc_hd__nand3_2
Xinput28 b_top[5] VSS VSS VDD VDD net28 sky130_fd_sc_hd__clkdlybuf4s50_1
X_08491_ net98 VSS VSS VDD VDD _02825_ sky130_fd_sc_hd__inv_1
X_08492_ _02822_ _02825_ VSS VSS VDD VDD _02826_ sky130_fd_sc_hd__nand2_1
X_08493_ _02811_ _02815_ net98 _02821_ VSS VSS VDD VDD _02827_
+ sky130_fd_sc_hd__nand4_1
X_08494_ _02826_ _02827_ VSS VSS VDD VDD _02828_ sky130_fd_sc_hd__nand2_1
X_08495_ net97 VSS VSS VDD VDD _02829_ sky130_fd_sc_hd__inv_1
X_08496_ _02822_ _02829_ VSS VSS VDD VDD _02830_ sky130_fd_sc_hd__nand2_1
X_08497_ _02811_ _02815_ net97 _02821_ VSS VSS VDD VDD _02831_
+ sky130_fd_sc_hd__nand4_1
X_08498_ _02830_ _02831_ VSS VSS VDD VDD _02832_ sky130_fd_sc_hd__nand2_2
X_08499_ _02828_ _02832_ VSS VSS VDD VDD _02833_ sky130_fd_sc_hd__nor2_1
X_08500_ net95 VSS VSS VDD VDD _02834_ sky130_fd_sc_hd__inv_1
X_08501_ _02822_ _02834_ VSS VSS VDD VDD _02836_ sky130_fd_sc_hd__nand2_1
X_08502_ _02811_ _02815_ net95 _02821_ VSS VSS VDD VDD _02837_
+ sky130_fd_sc_hd__nand4_1
X_08503_ _02836_ _02837_ VSS VSS VDD VDD _02838_ sky130_fd_sc_hd__nand2_2
X_08504_ net94 VSS VSS VDD VDD _02839_ sky130_fd_sc_hd__inv_1
X_08505_ _02822_ _02839_ VSS VSS VDD VDD _02840_ sky130_fd_sc_hd__nand2_2
X_08506_ _02811_ _02815_ net94 _02821_ VSS VSS VDD VDD _02841_
+ sky130_fd_sc_hd__nand4_1
X_08507_ _02840_ _02841_ VSS VSS VDD VDD _02842_ sky130_fd_sc_hd__nand2_2
X_08508_ _02838_ _02842_ VSS VSS VDD VDD _02843_ sky130_fd_sc_hd__nor2_2
X_08509_ _02833_ _02843_ VSS VSS VDD VDD _02844_ sky130_fd_sc_hd__nand2_1
X_08510_ net91 VSS VSS VDD VDD _02845_ sky130_fd_sc_hd__inv_1
X_08511_ _02822_ _02845_ VSS VSS VDD VDD _02847_ sky130_fd_sc_hd__nand2_4
X_08512_ _02811_ _02815_ net91 _02821_ VSS VSS VDD VDD _02848_
+ sky130_fd_sc_hd__nand4_1
X_08513_ _02847_ _02848_ VSS VSS VDD VDD _02849_ sky130_fd_sc_hd__nand2_4
X_08514_ _02664_ _02589_ VSS VSS VDD VDD _02850_ sky130_fd_sc_hd__nand2_1
X_08515_ _02850_ _02709_ VSS VSS VDD VDD _02851_ sky130_fd_sc_hd__nor2_1
X_08516_ _02682_ _02851_ VSS VSS VDD VDD _02852_ sky130_fd_sc_hd__nand2_1
X_08517_ _02596_ _02660_ _02658_ VSS VSS VDD VDD _02853_ sky130_fd_sc_hd__o21ai_0
X_08518_ _02707_ _02850_ VSS VSS VDD VDD _02854_ sky130_fd_sc_hd__nor2_1
X_08519_ _02853_ _02854_ VSS VSS VDD VDD _02855_ sky130_fd_sc_hd__nor2_1
X_08520_ _02852_ _02855_ VSS VSS VDD VDD _02856_ sky130_fd_sc_hd__nand2_1
X_08521_ _02856_ _02809_ VSS VSS VDD VDD _02858_ sky130_fd_sc_hd__nand2_1
X_08522_ _02809_ VSS VSS VDD VDD _02859_ sky130_fd_sc_hd__inv_1
X_08523_ _02852_ _02859_ _02855_ VSS VSS VDD VDD _02860_ sky130_fd_sc_hd__nand3_1
X_08524_ net90 _02858_ _02860_ VSS VSS VDD VDD _02861_ sky130_fd_sc_hd__nand3b_1
X_08525_ _02856_ _02859_ VSS VSS VDD VDD _02862_ sky130_fd_sc_hd__nand2_1
X_08526_ _02852_ _02809_ _02855_ VSS VSS VDD VDD _02863_ sky130_fd_sc_hd__nand3_1
X_08527_ _02862_ net90 _02863_ VSS VSS VDD VDD _02864_ sky130_fd_sc_hd__nand3_1
X_08528_ _02861_ _02864_ VSS VSS VDD VDD _02865_ sky130_fd_sc_hd__nand2_1
X_08529_ _02849_ _02865_ VSS VSS VDD VDD _02866_ sky130_fd_sc_hd__nor2_4
X_08530_ net93 VSS VSS VDD VDD _02867_ sky130_fd_sc_hd__inv_1
X_08531_ _02822_ _02867_ VSS VSS VDD VDD _02869_ sky130_fd_sc_hd__nand2_1
X_08532_ _02811_ _02815_ net93 _02821_ VSS VSS VDD VDD _02870_
+ sky130_fd_sc_hd__nand4_1
X_08533_ _02869_ _02870_ VSS VSS VDD VDD _02871_ sky130_fd_sc_hd__nand2_2
X_08534_ net92 VSS VSS VDD VDD _02872_ sky130_fd_sc_hd__inv_1
X_08535_ _02822_ _02872_ VSS VSS VDD VDD _02873_ sky130_fd_sc_hd__nand2_4
X_08536_ _02811_ _02815_ net92 _02821_ VSS VSS VDD VDD _02874_
+ sky130_fd_sc_hd__nand4_1
X_08537_ _02873_ _02874_ VSS VSS VDD VDD _02875_ sky130_fd_sc_hd__nand2_4
X_08538_ _02871_ _02875_ VSS VSS VDD VDD _02876_ sky130_fd_sc_hd__nor2_1
X_08539_ _02866_ _02876_ VSS VSS VDD VDD _02877_ sky130_fd_sc_hd__nand2_1
X_08540_ _02844_ _02877_ VSS VSS VDD VDD _02878_ sky130_fd_sc_hd__nor2_2
X_08541_ _02773_ _02878_ VSS VSS VDD VDD _02880_ sky130_fd_sc_hd__nand2_1
X_08542_ _02864_ _02848_ VSS VSS VDD VDD _02881_ sky130_fd_sc_hd__nand2_1
X_08543_ _02881_ _02847_ VSS VSS VDD VDD _02882_ sky130_fd_sc_hd__nand2_1
X_08544_ _02882_ VSS VSS VDD VDD _02883_ sky130_fd_sc_hd__inv_1
X_08545_ _02883_ _02876_ VSS VSS VDD VDD _02884_ sky130_fd_sc_hd__nand2_1
X_08546_ _02870_ _02874_ VSS VSS VDD VDD _02885_ sky130_fd_sc_hd__nand2_1
X_08547_ _02885_ VSS VSS VDD VDD _02886_ sky130_fd_sc_hd__inv_1
X_08548_ _02884_ _02886_ VSS VSS VDD VDD _02887_ sky130_fd_sc_hd__nand2_1
X_08549_ _02844_ VSS VSS VDD VDD _02888_ sky130_fd_sc_hd__inv_1
X_08550_ _02822_ VSS VSS VDD VDD _02889_ sky130_fd_sc_hd__inv_1
X_08551_ net94 net95 net97 net98 _02889_ VSS VSS VDD VDD _02891_
+ sky130_fd_sc_hd__o41ai_1
X_08552_ _02891_ VSS VSS VDD VDD _02892_ sky130_fd_sc_hd__inv_1
X_08553_ _02887_ _02888_ _02892_ VSS VSS VDD VDD _02893_ sky130_fd_sc_hd__a21oi_1
X_08554_ net106 VSS VSS VDD VDD _02894_ sky130_fd_sc_hd__inv_1
X_08555_ _02732_ _02894_ VSS VSS VDD VDD _02895_ sky130_fd_sc_hd__nand2_1
X_08556_ _02729_ _02731_ net106 VSS VSS VDD VDD _02896_ sky130_fd_sc_hd__nand3_1
X_08557_ net105 VSS VSS VDD VDD _02897_ sky130_fd_sc_hd__inv_1
X_08558_ _02738_ _02739_ _02897_ VSS VSS VDD VDD _02898_ sky130_fd_sc_hd__nand3_1
X_08559_ _02741_ _02898_ VSS VSS VDD VDD _02899_ sky130_fd_sc_hd__nand2_1
X_08560_ _02895_ _02896_ _02899_ VSS VSS VDD VDD _02900_ sky130_fd_sc_hd__a21oi_1
X_08561_ _02728_ _02900_ _02751_ VSS VSS VDD VDD _02902_ sky130_fd_sc_hd__nand3_1
X_08562_ _02672_ _02720_ _02702_ VSS VSS VDD VDD _02903_ sky130_fd_sc_hd__nand3_1
X_08563_ _02902_ _02903_ VSS VSS VDD VDD _02904_ sky130_fd_sc_hd__nor2_1
X_08564_ _02250_ _02198_ VSS VSS VDD VDD _02905_ sky130_fd_sc_hd__nand2_1
X_08565_ _02248_ _02249_ _02199_ VSS VSS VDD VDD _02906_ sky130_fd_sc_hd__nand3_1
X_08566_ _02213_ _02215_ _02198_ VSS VSS VDD VDD _02907_ sky130_fd_sc_hd__nand3b_1
X_08567_ _02905_ _02906_ _02907_ VSS VSS VDD VDD _02908_ sky130_fd_sc_hd__nand3_1
X_08568_ _02250_ _02217_ VSS VSS VDD VDD _02909_ sky130_fd_sc_hd__nand2_1
X_08569_ _02908_ net104 _02909_ VSS VSS VDD VDD _02910_ sky130_fd_sc_hd__nand3_1
X_08570_ net103 VSS VSS VDD VDD _02911_ sky130_fd_sc_hd__inv_1
X_08571_ _02216_ _02213_ VSS VSS VDD VDD _02913_ sky130_fd_sc_hd__nand2_1
X_08572_ _02913_ _02907_ VSS VSS VDD VDD _02914_ sky130_fd_sc_hd__nand2_1
X_08573_ _02911_ _02914_ VSS VSS VDD VDD _02915_ sky130_fd_sc_hd__nor2_1
X_08574_ net102 VSS VSS VDD VDD _02916_ sky130_fd_sc_hd__inv_1
X_08575_ _02201_ _02210_ _02211_ VSS VSS VDD VDD _02917_ sky130_fd_sc_hd__nand3_1
X_08576_ _02213_ _02917_ VSS VSS VDD VDD _02918_ sky130_fd_sc_hd__nand2_1
X_08577_ _02916_ _02918_ VSS VSS VDD VDD _02919_ sky130_fd_sc_hd__nor2_1
X_08578_ _02213_ _02917_ net102 VSS VSS VDD VDD _02920_ sky130_fd_sc_hd__a21oi_1
X_08579_ _02919_ _02920_ VSS VSS VDD VDD _02921_ sky130_fd_sc_hd__nor2_1
X_08580_ net101 VSS VSS VDD VDD _02922_ sky130_fd_sc_hd__inv_1
X_08581_ _02209_ _02210_ VSS VSS VDD VDD _02924_ sky130_fd_sc_hd__nand2_1
X_08582_ _02924_ _02179_ VSS VSS VDD VDD _02925_ sky130_fd_sc_hd__nand2_1
X_08583_ _02925_ _02211_ VSS VSS VDD VDD _02926_ sky130_fd_sc_hd__nand2_1
X_08584_ net96 VSS VSS VDD VDD _02927_ sky130_fd_sc_hd__inv_1
X_08585_ wrapped_design.b00_down\[1\] wrapped_design.a1_skew\[0\]
+ VSS VSS VDD VDD _02928_ sky130_fd_sc_hd__nand2_1
X_08586_ _02011_ _00684_ _02928_ VSS VSS VDD VDD _02929_ sky130_fd_sc_hd__o21ai_0
X_08587_ _02929_ _02208_ VSS VSS VDD VDD _02930_ sky130_fd_sc_hd__nand2_1
X_08588_ _02927_ _02930_ VSS VSS VDD VDD _02931_ sky130_fd_sc_hd__nor2_1
X_08589_ net85 VSS VSS VDD VDD _02932_ sky130_fd_sc_hd__inv_1
X_08590_ _02930_ VSS VSS VDD VDD _02933_ sky130_fd_sc_hd__inv_1
X_08591_ net96 _02933_ VSS VSS VDD VDD _02935_ sky130_fd_sc_hd__nor2_1
X_08592_ _02932_ _02206_ _02931_ _02935_ VSS VSS VDD VDD _02936_
+ sky130_fd_sc_hd__nor4_1
X_08593_ _02922_ _02926_ VSS VSS VDD VDD _02937_ sky130_fd_sc_hd__nor2_1
X_08594_ _02925_ _02211_ net101 VSS VSS VDD VDD _02938_ sky130_fd_sc_hd__a21oi_1
X_08595_ _02937_ _02938_ VSS VSS VDD VDD _02939_ sky130_fd_sc_hd__nor2_1
X_08596_ _02931_ _02936_ _02939_ VSS VSS VDD VDD _02940_ sky130_fd_sc_hd__o21ai_0
X_08597_ _02922_ _02926_ _02940_ VSS VSS VDD VDD _02941_ sky130_fd_sc_hd__o21ai_0
X_08598_ _02921_ _02941_ VSS VSS VDD VDD _02942_ sky130_fd_sc_hd__nand2_1
X_08599_ _02919_ VSS VSS VDD VDD _02943_ sky130_fd_sc_hd__inv_1
X_08600_ _02942_ _02943_ VSS VSS VDD VDD _02944_ sky130_fd_sc_hd__nand2_1
X_08601_ _02914_ _02911_ VSS VSS VDD VDD _02946_ sky130_fd_sc_hd__nand2_1
X_08602_ _02915_ _02944_ _02946_ VSS VSS VDD VDD _02947_ sky130_fd_sc_hd__o21ai_0
X_08603_ _02910_ _02947_ VSS VSS VDD VDD _02948_ sky130_fd_sc_hd__nand2_1
X_08604_ _02905_ _02906_ VSS VSS VDD VDD _02949_ sky130_fd_sc_hd__nand2_1
X_08605_ _02949_ _02907_ VSS VSS VDD VDD _02950_ sky130_fd_sc_hd__nand2_1
X_08606_ _02905_ _02906_ _02217_ VSS VSS VDD VDD _02951_ sky130_fd_sc_hd__nand3_1
X_08607_ net104 VSS VSS VDD VDD _02952_ sky130_fd_sc_hd__inv_1
X_08608_ _02950_ _02951_ _02952_ VSS VSS VDD VDD _02953_ sky130_fd_sc_hd__nand3_1
X_08609_ _02948_ _02953_ VSS VSS VDD VDD _02954_ sky130_fd_sc_hd__nand2_1
X_08610_ _02954_ VSS VSS VDD VDD _02955_ sky130_fd_sc_hd__inv_1
X_08611_ _02878_ _02904_ _02955_ VSS VSS VDD VDD _02957_ sky130_fd_sc_hd__nand3_1
X_08612_ _02889_ net99 VSS VSS VDD VDD _02958_ sky130_fd_sc_hd__nand2_1
X_08613_ net99 VSS VSS VDD VDD _02959_ sky130_fd_sc_hd__inv_1
X_08614_ _02822_ _02959_ VSS VSS VDD VDD _02960_ sky130_fd_sc_hd__nand2_1
X_08615_ _02958_ _02960_ VSS VSS VDD VDD _02961_ sky130_fd_sc_hd__nand2_1
X_08616_ _02880_ _02893_ _02957_ _02961_ VSS VSS VDD VDD _02962_
+ sky130_fd_sc_hd__nand4_1
X_08617_ _02880_ _02893_ _02957_ VSS VSS VDD VDD _02963_ sky130_fd_sc_hd__nand3_1
X_08618_ _02961_ VSS VSS VDD VDD _02964_ sky130_fd_sc_hd__inv_1
X_08619_ _02963_ _02964_ VSS VSS VDD VDD _02965_ sky130_fd_sc_hd__nand2_1
X_08620_ net158 VSS VSS VDD VDD _02966_ sky130_fd_sc_hd__clkinv_1
Xinput27 b_top[4] VSS VSS VDD VDD net27 sky130_fd_sc_hd__clkdlybuf4s50_1
X_08622_ _02962_ _02965_ net154 VSS VSS VDD VDD _02969_ sky130_fd_sc_hd__nand3_1
X_08623_ net157 VSS VSS VDD VDD _02970_ sky130_fd_sc_hd__clkinv_1
Xinput26 b_top[3] VSS VSS VDD VDD net26 sky130_fd_sc_hd__clkdlybuf4s50_1
X_08625_ _02822_ net157 VSS VSS VDD VDD _02972_ sky130_fd_sc_hd__nand2_1
X_08626_ net153 net158 _02972_ VSS VSS VDD VDD _02973_ sky130_fd_sc_hd__o21ai_1
X_08627_ net157 net99 net161 VSS VSS VDD VDD _02974_ sky130_fd_sc_hd__o21ai_0
X_08628_ _02969_ _02973_ _02974_ VSS VSS VDD VDD _00067_ sky130_fd_sc_hd__a21oi_1
X_08629_ _02875_ _02849_ VSS VSS VDD VDD _02975_ sky130_fd_sc_hd__nor2_4
X_08630_ _02975_ VSS VSS VDD VDD _02976_ sky130_fd_sc_hd__inv_1
X_08631_ _02672_ _02864_ _02861_ VSS VSS VDD VDD _02978_ sky130_fd_sc_hd__nand3_1
X_08632_ _02976_ _02978_ VSS VSS VDD VDD _02979_ sky130_fd_sc_hd__nor2_1
X_08633_ _02712_ _02717_ _02715_ VSS VSS VDD VDD _02980_ sky130_fd_sc_hd__nand3_1
X_08634_ _02764_ _02980_ VSS VSS VDD VDD _02981_ sky130_fd_sc_hd__nand2_1
X_08635_ _02701_ _02981_ VSS VSS VDD VDD _02982_ sky130_fd_sc_hd__nor2_1
X_08636_ _02895_ _02896_ VSS VSS VDD VDD _02983_ sky130_fd_sc_hd__nand2_1
X_08637_ _02898_ _02948_ _02953_ VSS VSS VDD VDD _02984_ sky130_fd_sc_hd__nand3_1
X_08638_ _02984_ _02741_ VSS VSS VDD VDD _02985_ sky130_fd_sc_hd__nand2_1
X_08639_ _02983_ _02985_ VSS VSS VDD VDD _02986_ sky130_fd_sc_hd__nand2_1
X_08640_ _02986_ VSS VSS VDD VDD _02987_ sky130_fd_sc_hd__inv_1
X_08641_ _02987_ _02751_ VSS VSS VDD VDD _02989_ sky130_fd_sc_hd__nand2_1
X_08642_ _02756_ _02733_ VSS VSS VDD VDD _02990_ sky130_fd_sc_hd__nand2_1
X_08643_ net107 _02746_ _02990_ VSS VSS VDD VDD _02991_ sky130_fd_sc_hd__o21ai_0
X_08644_ _02989_ _02991_ VSS VSS VDD VDD _02992_ sky130_fd_sc_hd__nand2_1
X_08645_ _02992_ _02728_ VSS VSS VDD VDD _02993_ sky130_fd_sc_hd__nand2_1
X_08646_ _02689_ _02753_ VSS VSS VDD VDD _02994_ sky130_fd_sc_hd__nand2_1
X_08647_ _02994_ VSS VSS VDD VDD _02995_ sky130_fd_sc_hd__inv_1
X_08648_ _02993_ _02995_ VSS VSS VDD VDD _02996_ sky130_fd_sc_hd__nand2_1
X_08649_ _02982_ _02691_ _02996_ VSS VSS VDD VDD _02997_ sky130_fd_sc_hd__nand3_1
X_08650_ _02764_ _02700_ VSS VSS VDD VDD _02998_ sky130_fd_sc_hd__nand2_1
X_08651_ _02998_ _02980_ VSS VSS VDD VDD _03000_ sky130_fd_sc_hd__nand2_1
X_08652_ _02997_ _03000_ VSS VSS VDD VDD _03001_ sky130_fd_sc_hd__nand2_1
X_08653_ _02979_ _03001_ VSS VSS VDD VDD _03002_ sky130_fd_sc_hd__nand2_1
X_08654_ _02861_ VSS VSS VDD VDD _03003_ sky130_fd_sc_hd__inv_2
X_08655_ _03003_ _02763_ _02864_ VSS VSS VDD VDD _03004_ sky130_fd_sc_hd__o21ai_0
X_08656_ _02874_ _02848_ VSS VSS VDD VDD _03005_ sky130_fd_sc_hd__nand2_1
X_08657_ _03004_ _02975_ _03005_ VSS VSS VDD VDD _03006_ sky130_fd_sc_hd__a21oi_1
X_08658_ _03002_ _03006_ VSS VSS VDD VDD _03007_ sky130_fd_sc_hd__nand2_1
X_08659_ _02832_ _02838_ _02842_ _02871_ VSS VSS VDD VDD _03008_
+ sky130_fd_sc_hd__nor4_1
X_08660_ _03007_ _03008_ VSS VSS VDD VDD _03009_ sky130_fd_sc_hd__nand2_1
X_08661_ net93 net94 net95 net97 _02889_ VSS VSS VDD VDD _03011_
+ sky130_fd_sc_hd__o41ai_1
X_08662_ _03009_ _03011_ VSS VSS VDD VDD _03012_ sky130_fd_sc_hd__nand2_1
X_08663_ _02828_ VSS VSS VDD VDD _03013_ sky130_fd_sc_hd__inv_1
X_08664_ _03012_ _03013_ VSS VSS VDD VDD _03014_ sky130_fd_sc_hd__nand2_1
X_08665_ _03009_ _02828_ _03011_ VSS VSS VDD VDD _03015_ sky130_fd_sc_hd__nand3_1
X_08666_ _03014_ net154 _03015_ VSS VSS VDD VDD _03016_ sky130_fd_sc_hd__nand3_1
X_08667_ net157 net98 net161 VSS VSS VDD VDD _03017_ sky130_fd_sc_hd__o21ai_0
X_08668_ _03016_ _02973_ _03017_ VSS VSS VDD VDD _00068_ sky130_fd_sc_hd__a21oi_1
X_08669_ _02672_ _02720_ VSS VSS VDD VDD _03018_ sky130_fd_sc_hd__nand2_1
X_08670_ _02985_ VSS VSS VDD VDD _03019_ sky130_fd_sc_hd__inv_1
X_08671_ _02742_ _03019_ _02733_ VSS VSS VDD VDD _03021_ sky130_fd_sc_hd__o21ai_0
X_08672_ _03021_ _02751_ VSS VSS VDD VDD _03022_ sky130_fd_sc_hd__nand2_1
X_08673_ _02757_ VSS VSS VDD VDD _03023_ sky130_fd_sc_hd__inv_1
X_08674_ _03022_ _03023_ VSS VSS VDD VDD _03024_ sky130_fd_sc_hd__nand2_1
X_08675_ _02693_ _03024_ _02759_ VSS VSS VDD VDD _03025_ sky130_fd_sc_hd__nand3b_1
X_08676_ _02770_ VSS VSS VDD VDD _03026_ sky130_fd_sc_hd__inv_1
X_08677_ _03025_ _03026_ VSS VSS VDD VDD _03027_ sky130_fd_sc_hd__nand2_1
X_08678_ _03027_ _02699_ VSS VSS VDD VDD _03028_ sky130_fd_sc_hd__nand2_1
X_08679_ _03018_ _03028_ VSS VSS VDD VDD _03029_ sky130_fd_sc_hd__nor2_1
X_08680_ _02871_ VSS VSS VDD VDD _03030_ sky130_fd_sc_hd__inv_1
X_08681_ _02875_ VSS VSS VDD VDD _03032_ sky130_fd_sc_hd__inv_1
X_08682_ _02843_ _03030_ _03032_ VSS VSS VDD VDD _03033_ sky130_fd_sc_hd__and3_1
X_08683_ _03029_ _03033_ _02866_ VSS VSS VDD VDD _03034_ sky130_fd_sc_hd__nand3_1
X_08684_ _02866_ VSS VSS VDD VDD _03035_ sky130_fd_sc_hd__inv_2
X_08685_ _02768_ _03035_ _02882_ VSS VSS VDD VDD _03036_ sky130_fd_sc_hd__o21ai_1
X_08686_ _03036_ _03033_ VSS VSS VDD VDD _03037_ sky130_fd_sc_hd__nand2_1
X_08687_ _02837_ _02841_ VSS VSS VDD VDD _03038_ sky130_fd_sc_hd__nand2_1
X_08688_ _02843_ _02885_ _03038_ VSS VSS VDD VDD _03039_ sky130_fd_sc_hd__a21oi_1
X_08689_ _03034_ _03037_ _03039_ VSS VSS VDD VDD _03040_ sky130_fd_sc_hd__nand3_1
X_08690_ _02832_ VSS VSS VDD VDD _03041_ sky130_fd_sc_hd__inv_1
X_08691_ _03040_ _03041_ VSS VSS VDD VDD _03043_ sky130_fd_sc_hd__nand2_1
X_08692_ _03034_ _03037_ _02832_ _03039_ VSS VSS VDD VDD _03044_
+ sky130_fd_sc_hd__nand4_1
X_08693_ _03043_ _03044_ net154 VSS VSS VDD VDD _03045_ sky130_fd_sc_hd__nand3_1
Xinput25 b_top[2] VSS VSS VDD VDD net25 sky130_fd_sc_hd__clkdlybuf4s50_1
X_08695_ net157 net97 net161 VSS VSS VDD VDD _03047_ sky130_fd_sc_hd__o21ai_0
X_08696_ _03045_ _02973_ _03047_ VSS VSS VDD VDD _00069_ sky130_fd_sc_hd__a21oi_1
X_08697_ _02864_ VSS VSS VDD VDD _03048_ sky130_fd_sc_hd__inv_1
X_08698_ _03003_ _02763_ VSS VSS VDD VDD _03049_ sky130_fd_sc_hd__nor2_1
X_08699_ _03048_ _03049_ VSS VSS VDD VDD _03050_ sky130_fd_sc_hd__nor2_1
X_08700_ _02997_ _03050_ _03000_ VSS VSS VDD VDD _03051_ sky130_fd_sc_hd__nand3_1
X_08701_ _02842_ _02871_ VSS VSS VDD VDD _03053_ sky130_fd_sc_hd__nor2_2
X_08702_ _02978_ _03050_ VSS VSS VDD VDD _03054_ sky130_fd_sc_hd__nand2_1
X_08703_ _03051_ _03053_ _02975_ _03054_ VSS VSS VDD VDD _03055_
+ sky130_fd_sc_hd__nand4_1
X_08704_ net91 net92 net93 net94 _02889_ VSS VSS VDD VDD _03056_
+ sky130_fd_sc_hd__o41ai_1
X_08705_ _03055_ _03056_ VSS VSS VDD VDD _03057_ sky130_fd_sc_hd__nand2_1
X_08706_ _02838_ VSS VSS VDD VDD _03058_ sky130_fd_sc_hd__inv_1
X_08707_ _03057_ _03058_ VSS VSS VDD VDD _03059_ sky130_fd_sc_hd__nand2_1
X_08708_ _03055_ _02838_ _03056_ VSS VSS VDD VDD _03060_ sky130_fd_sc_hd__nand3_1
X_08709_ _03059_ net154 _03060_ VSS VSS VDD VDD _03061_ sky130_fd_sc_hd__nand3_1
X_08710_ net157 net95 net161 VSS VSS VDD VDD _03062_ sky130_fd_sc_hd__o21ai_0
X_08711_ _03061_ _02973_ _03062_ VSS VSS VDD VDD _00070_ sky130_fd_sc_hd__a21oi_1
X_08712_ _03018_ _03028_ _02768_ VSS VSS VDD VDD _03064_ sky130_fd_sc_hd__o21ai_1
X_08713_ _02877_ VSS VSS VDD VDD _03065_ sky130_fd_sc_hd__inv_1
X_08714_ _03064_ _03065_ VSS VSS VDD VDD _03066_ sky130_fd_sc_hd__nand2_1
X_08715_ _02887_ VSS VSS VDD VDD _03067_ sky130_fd_sc_hd__inv_1
X_08716_ _03066_ _03067_ VSS VSS VDD VDD _03068_ sky130_fd_sc_hd__nand2_1
X_08717_ _02842_ VSS VSS VDD VDD _03069_ sky130_fd_sc_hd__inv_1
X_08718_ _03068_ _03069_ VSS VSS VDD VDD _03070_ sky130_fd_sc_hd__nand2_1
X_08719_ _03066_ _02842_ _03067_ VSS VSS VDD VDD _03071_ sky130_fd_sc_hd__nand3_1
X_08720_ _03070_ net154 _03071_ VSS VSS VDD VDD _03072_ sky130_fd_sc_hd__nand3_1
Xinput24 b_top[1] VSS VSS VDD VDD net24 sky130_fd_sc_hd__clkdlybuf4s50_1
X_08722_ net157 net94 net161 VSS VSS VDD VDD _03075_ sky130_fd_sc_hd__o21ai_0
X_08723_ _03072_ _02973_ _03075_ VSS VSS VDD VDD _00071_ sky130_fd_sc_hd__a21oi_1
X_08724_ _03007_ _03030_ VSS VSS VDD VDD _03076_ sky130_fd_sc_hd__nand2_1
X_08725_ _03002_ _03006_ _02871_ VSS VSS VDD VDD _03077_ sky130_fd_sc_hd__nand3_1
Xinput23 b_top[15] VSS VSS VDD VDD net23 sky130_fd_sc_hd__clkdlybuf4s50_1
X_08727_ _03076_ _03077_ net154 VSS VSS VDD VDD _03079_ sky130_fd_sc_hd__nand3_1
X_08728_ net157 net93 net161 VSS VSS VDD VDD _03080_ sky130_fd_sc_hd__o21ai_0
X_08729_ _03079_ _02973_ _03080_ VSS VSS VDD VDD _00072_ sky130_fd_sc_hd__a21oi_1
X_08730_ _03029_ _02866_ VSS VSS VDD VDD _03081_ sky130_fd_sc_hd__nand2_1
X_08731_ _03036_ VSS VSS VDD VDD _03083_ sky130_fd_sc_hd__inv_1
X_08732_ _03081_ _03083_ VSS VSS VDD VDD _03084_ sky130_fd_sc_hd__nand2_1
X_08733_ _03084_ _03032_ VSS VSS VDD VDD _03085_ sky130_fd_sc_hd__nand2_1
X_08734_ _03081_ _03083_ _02875_ VSS VSS VDD VDD _03086_ sky130_fd_sc_hd__nand3_1
X_08735_ _03085_ _03086_ net154 VSS VSS VDD VDD _03087_ sky130_fd_sc_hd__nand3_1
X_08736_ net157 net92 net161 VSS VSS VDD VDD _03088_ sky130_fd_sc_hd__o21ai_0
X_08737_ _03087_ _02973_ _03088_ VSS VSS VDD VDD _00073_ sky130_fd_sc_hd__a21oi_1
X_08738_ _03051_ _03054_ VSS VSS VDD VDD _03089_ sky130_fd_sc_hd__nand2_1
X_08739_ _02847_ _02848_ _03089_ VSS VSS VDD VDD _03090_ sky130_fd_sc_hd__a21oi_1
X_08740_ _03051_ _03054_ _02849_ VSS VSS VDD VDD _03091_ sky130_fd_sc_hd__a21oi_1
X_08741_ _03090_ _03091_ net154 VSS VSS VDD VDD _03093_ sky130_fd_sc_hd__o21ai_0
X_08742_ net157 net91 net161 VSS VSS VDD VDD _03094_ sky130_fd_sc_hd__o21ai_0
X_08743_ _03093_ _02973_ _03094_ VSS VSS VDD VDD _00074_ sky130_fd_sc_hd__a21oi_1
X_08744_ _02865_ _03064_ VSS VSS VDD VDD _03095_ sky130_fd_sc_hd__xor2_1
X_08745_ _03095_ net154 VSS VSS VDD VDD _03096_ sky130_fd_sc_hd__nand2_1
X_08746_ _02858_ net158 _02860_ VSS VSS VDD VDD _03097_ sky130_fd_sc_hd__nand3_1
X_08747_ _03097_ net157 VSS VSS VDD VDD _03098_ sky130_fd_sc_hd__nand2_1
X_08748_ _03098_ VSS VSS VDD VDD _03099_ sky130_fd_sc_hd__inv_1
X_08749_ _03096_ _03099_ VSS VSS VDD VDD _03100_ sky130_fd_sc_hd__nand2_1
Xinput22 b_top[14] VSS VSS VDD VDD net22 sky130_fd_sc_hd__clkdlybuf4s50_1
X_08751_ net153 net90 VSS VSS VDD VDD _03103_ sky130_fd_sc_hd__nand2_1
X_08752_ _03100_ _03103_ net164 VSS VSS VDD VDD _00075_ sky130_fd_sc_hd__a21oi_1
X_08753_ _03001_ _02666_ _02671_ VSS VSS VDD VDD _03104_ sky130_fd_sc_hd__nand3_1
Xinput21 b_top[13] VSS VSS VDD VDD net21 sky130_fd_sc_hd__clkdlybuf4s50_1
X_08755_ _02997_ _02672_ _03000_ VSS VSS VDD VDD _03106_ sky130_fd_sc_hd__nand3_1
X_08756_ _03104_ net154 _03106_ VSS VSS VDD VDD _03107_ sky130_fd_sc_hd__nand3_1
Xinput20 b_top[12] VSS VSS VDD VDD net20 sky130_fd_sc_hd__clkdlybuf4s50_1
Xinput19 b_top[11] VSS VSS VDD VDD net19 sky130_fd_sc_hd__clkdlybuf4s50_1
X_08759_ _02766_ net158 VSS VSS VDD VDD _03110_ sky130_fd_sc_hd__nand2_1
X_08760_ _03107_ net157 _03110_ VSS VSS VDD VDD _03111_ sky130_fd_sc_hd__nand3_1
X_08761_ net153 net89 VSS VSS VDD VDD _03113_ sky130_fd_sc_hd__nand2_1
X_08762_ _03111_ _03113_ net164 VSS VSS VDD VDD _00076_ sky130_fd_sc_hd__a21oi_1
X_08763_ _02720_ _03028_ VSS VSS VDD VDD _03114_ sky130_fd_sc_hd__xor2_1
X_08764_ _03114_ net154 VSS VSS VDD VDD _03115_ sky130_fd_sc_hd__nand2_1
X_08765_ net154 _02716_ net157 _03115_ VSS VSS VDD VDD _03116_
+ sky130_fd_sc_hd__o211ai_1
X_08766_ net153 net88 VSS VSS VDD VDD _03117_ sky130_fd_sc_hd__nand2_1
X_08767_ _03116_ _03117_ net164 VSS VSS VDD VDD _00077_ sky130_fd_sc_hd__a21oi_1
X_08768_ _02996_ _02691_ _02701_ VSS VSS VDD VDD _03118_ sky130_fd_sc_hd__a21oi_1
X_08769_ _02996_ _02691_ VSS VSS VDD VDD _03119_ sky130_fd_sc_hd__nand2_1
X_08770_ _02699_ _02700_ _03119_ VSS VSS VDD VDD _03120_ sky130_fd_sc_hd__a21oi_1
X_08771_ _03118_ _03120_ net154 VSS VSS VDD VDD _03122_ sky130_fd_sc_hd__o21ai_0
X_08772_ _02694_ net158 _02696_ VSS VSS VDD VDD _03123_ sky130_fd_sc_hd__nand3_1
Xinput18 b_top[10] VSS VSS VDD VDD net18 sky130_fd_sc_hd__clkdlybuf4s50_1
X_08774_ net157 net87 net161 VSS VSS VDD VDD _03125_ sky130_fd_sc_hd__o21ai_0
X_08775_ _03122_ net157 _03123_ _03125_ VSS VSS VDD VDD _00078_
+ sky130_fd_sc_hd__a31oi_1
X_08776_ _03024_ _02759_ VSS VSS VDD VDD _03126_ sky130_fd_sc_hd__nand2_1
X_08777_ _03126_ _02693_ VSS VSS VDD VDD _03127_ sky130_fd_sc_hd__nand2_1
X_08778_ net158 net153 VSS VSS VDD VDD _03128_ sky130_fd_sc_hd__nor2_1
Xinput17 b_top[0] VSS VSS VDD VDD net17 sky130_fd_sc_hd__clkdlybuf4s50_1
X_08780_ _03127_ _03025_ _03128_ VSS VSS VDD VDD _03130_ sky130_fd_sc_hd__nand3_1
Xinput16 a_left[9] VSS VSS VDD VDD net16 sky130_fd_sc_hd__clkdlybuf4s50_1
X_08782_ net153 net86 VSS VSS VDD VDD _03133_ sky130_fd_sc_hd__nand2_1
X_08783_ net156 net158 VSS VSS VDD VDD _03134_ sky130_fd_sc_hd__nand2_1
X_08784_ _03134_ VSS VSS VDD VDD _03135_ sky130_fd_sc_hd__inv_1
X_08785_ _02688_ _03135_ VSS VSS VDD VDD _03136_ sky130_fd_sc_hd__nand2_1
X_08786_ _03130_ _03133_ _03136_ net164 VSS VSS VDD VDD _00079_
+ sky130_fd_sc_hd__a31oi_1
X_08787_ _02989_ _02991_ _02727_ _02726_ VSS VSS VDD VDD _03137_
+ sky130_fd_sc_hd__nand4_1
X_08788_ _03137_ _03128_ _02993_ VSS VSS VDD VDD _03138_ sky130_fd_sc_hd__nand3_1
X_08789_ net153 net108 VSS VSS VDD VDD _03139_ sky130_fd_sc_hd__nand2_1
X_08790_ _02723_ _03135_ VSS VSS VDD VDD _03140_ sky130_fd_sc_hd__nand2_1
X_08791_ _03138_ _03139_ _03140_ net164 VSS VSS VDD VDD _00080_
+ sky130_fd_sc_hd__a31oi_1
X_08792_ _02751_ _03021_ VSS VSS VDD VDD _03142_ sky130_fd_sc_hd__or2_2
X_08793_ _02746_ _03135_ VSS VSS VDD VDD _03143_ sky130_fd_sc_hd__nand2_1
X_08794_ net157 _02748_ _03143_ VSS VSS VDD VDD _03144_ sky130_fd_sc_hd__o21ai_0
X_08795_ _03142_ _03022_ _03128_ _03144_ VSS VSS VDD VDD _03145_
+ sky130_fd_sc_hd__a31oi_1
X_08796_ net164 _03145_ VSS VSS VDD VDD _00081_ sky130_fd_sc_hd__nor2_1
X_08797_ _03019_ _02896_ _02895_ VSS VSS VDD VDD _03146_ sky130_fd_sc_hd__nand3_1
X_08798_ _03146_ _02966_ _02986_ VSS VSS VDD VDD _03147_ sky130_fd_sc_hd__nand3_1
Xinput15 a_left[8] VSS VSS VDD VDD net15 sky130_fd_sc_hd__clkdlybuf4s50_1
X_08800_ _02732_ net158 net153 VSS VSS VDD VDD _03149_ sky130_fd_sc_hd__a21oi_1
X_08801_ net153 _02894_ _03147_ _03149_ net164 VSS VSS VDD
+ VDD _00082_ sky130_fd_sc_hd__a221oi_1
Xinput14 a_left[7] VSS VSS VDD VDD net14 sky130_fd_sc_hd__clkdlybuf4s50_1
X_08803_ net153 _02897_ net164 VSS VSS VDD VDD _03152_ sky130_fd_sc_hd__a21oi_1
X_08804_ _02954_ _02899_ VSS VSS VDD VDD _03153_ sky130_fd_sc_hd__xnor2_1
X_08805_ _03153_ _03128_ VSS VSS VDD VDD _03154_ sky130_fd_sc_hd__nand2_1
X_08806_ _02740_ _03134_ _03152_ _03154_ VSS VSS VDD VDD _03155_
+ sky130_fd_sc_hd__o211ai_1
X_08807_ _03155_ VSS VSS VDD VDD _00083_ sky130_fd_sc_hd__inv_1
X_08808_ _02953_ VSS VSS VDD VDD _03156_ sky130_fd_sc_hd__inv_1
X_08809_ _03156_ _02948_ VSS VSS VDD VDD _03157_ sky130_fd_sc_hd__nor2_1
X_08810_ _02910_ VSS VSS VDD VDD _03158_ sky130_fd_sc_hd__inv_1
X_08811_ _03158_ _03156_ VSS VSS VDD VDD _03160_ sky130_fd_sc_hd__nor2_1
X_08812_ _02947_ _03160_ net154 VSS VSS VDD VDD _03161_ sky130_fd_sc_hd__o21ai_0
X_08813_ _02950_ _02951_ net158 VSS VSS VDD VDD _03162_ sky130_fd_sc_hd__nand3_1
X_08814_ _03157_ _03161_ net157 _03162_ VSS VSS VDD VDD _03163_
+ sky130_fd_sc_hd__o211ai_1
X_08815_ net153 net104 VSS VSS VDD VDD _03164_ sky130_fd_sc_hd__nand2_1
X_08816_ _03163_ _03164_ net164 VSS VSS VDD VDD _00084_ sky130_fd_sc_hd__a21oi_1
X_08817_ _02946_ VSS VSS VDD VDD _03165_ sky130_fd_sc_hd__inv_1
X_08818_ _02915_ _03165_ VSS VSS VDD VDD _03166_ sky130_fd_sc_hd__nor2_1
X_08819_ _02944_ _03166_ VSS VSS VDD VDD _03167_ sky130_fd_sc_hd__xor2_1
X_08820_ _03167_ net154 VSS VSS VDD VDD _03168_ sky130_fd_sc_hd__nand2_1
X_08821_ _02913_ _02907_ net158 VSS VSS VDD VDD _03170_ sky130_fd_sc_hd__nand3_1
X_08822_ net157 net103 net161 VSS VSS VDD VDD _03171_ sky130_fd_sc_hd__o21ai_0
X_08823_ _03168_ net157 _03170_ _03171_ VSS VSS VDD VDD _00085_
+ sky130_fd_sc_hd__a31oi_1
X_08824_ _02941_ _02921_ VSS VSS VDD VDD _03172_ sky130_fd_sc_hd__or2_2
X_08825_ _03172_ _02942_ _03128_ VSS VSS VDD VDD _03173_ sky130_fd_sc_hd__nand3_1
X_08826_ net157 _02916_ _03134_ _02918_ VSS VSS VDD VDD _03174_
+ sky130_fd_sc_hd__o22ai_1
X_08827_ _03174_ VSS VSS VDD VDD _03175_ sky130_fd_sc_hd__inv_1
X_08828_ _03173_ _03175_ net164 VSS VSS VDD VDD _00086_ sky130_fd_sc_hd__a21oi_1
X_08829_ net157 _02922_ _03134_ _02926_ VSS VSS VDD VDD _03176_
+ sky130_fd_sc_hd__o22ai_1
X_08830_ _02931_ _02936_ _02939_ VSS VSS VDD VDD _03177_ sky130_fd_sc_hd__nor3_1
X_08831_ _02940_ _03128_ VSS VSS VDD VDD _03179_ sky130_fd_sc_hd__nand2_1
X_08832_ _03177_ _03179_ VSS VSS VDD VDD _03180_ sky130_fd_sc_hd__nor2_1
X_08833_ _03176_ _03180_ net161 VSS VSS VDD VDD _00087_ sky130_fd_sc_hd__o21a_1
X_08834_ _02932_ _02206_ _02931_ _02935_ VSS VSS VDD VDD _03181_
+ sky130_fd_sc_hd__o22ai_1
X_08835_ _02936_ net154 _03181_ VSS VSS VDD VDD _03182_ sky130_fd_sc_hd__nand3b_1
X_08836_ _02933_ net158 net153 VSS VSS VDD VDD _03183_ sky130_fd_sc_hd__a21oi_1
X_08837_ net153 _02927_ _03182_ _03183_ net164 VSS VSS VDD
+ VDD _00088_ sky130_fd_sc_hd__a221oi_1
X_08838_ net153 _02206_ _02932_ _03135_ VSS VSS VDD VDD _03184_
+ sky130_fd_sc_hd__o22ai_1
X_08839_ _03184_ net161 VSS VSS VDD VDD _03185_ sky130_fd_sc_hd__nand2_1
X_08840_ net157 net85 _02207_ _03134_ _03185_ VSS VSS VDD
+ VDD _00089_ sky130_fd_sc_hd__a41oi_1
X_08841_ net29 net159 VSS VSS VDD VDD _03187_ sky130_fd_sc_hd__nor2_1
X_08842_ net163 wrapped_design.b00_down\[6\] net161 VSS VSS
+ VDD VDD _03188_ sky130_fd_sc_hd__o21ai_0
X_08843_ _03187_ _03188_ VSS VSS VDD VDD _00090_ sky130_fd_sc_hd__nor2_1
X_08844_ net28 net159 VSS VSS VDD VDD _03189_ sky130_fd_sc_hd__nor2_1
X_08845_ net163 wrapped_design.b00_down\[5\] net161 VSS VSS
+ VDD VDD _03190_ sky130_fd_sc_hd__o21ai_0
X_08846_ _03189_ _03190_ VSS VSS VDD VDD _00091_ sky130_fd_sc_hd__nor2_1
X_08847_ net27 net159 VSS VSS VDD VDD _03191_ sky130_fd_sc_hd__nor2_1
X_08848_ net163 wrapped_design.b00_down\[4\] net161 VSS VSS
+ VDD VDD _03192_ sky130_fd_sc_hd__o21ai_0
X_08849_ _03191_ _03192_ VSS VSS VDD VDD _00092_ sky130_fd_sc_hd__nor2_1
X_08850_ net26 net159 VSS VSS VDD VDD _03193_ sky130_fd_sc_hd__nor2_1
X_08851_ net163 wrapped_design.b00_down\[3\] net161 VSS VSS
+ VDD VDD _03195_ sky130_fd_sc_hd__o21ai_0
X_08852_ _03193_ _03195_ VSS VSS VDD VDD _00093_ sky130_fd_sc_hd__nor2_1
X_08853_ net25 net159 VSS VSS VDD VDD _03196_ sky130_fd_sc_hd__nor2_1
X_08854_ net163 wrapped_design.b00_down\[2\] net161 VSS VSS
+ VDD VDD _03197_ sky130_fd_sc_hd__o21ai_0
X_08855_ _03196_ _03197_ VSS VSS VDD VDD _00094_ sky130_fd_sc_hd__nor2_1
X_08856_ net24 _00664_ VSS VSS VDD VDD _03198_ sky130_fd_sc_hd__nor2_1
X_08857_ net163 wrapped_design.b00_down\[1\] net161 VSS VSS
+ VDD VDD _03199_ sky130_fd_sc_hd__o21ai_0
X_08858_ _03198_ _03199_ VSS VSS VDD VDD _00095_ sky130_fd_sc_hd__nor2_1
X_08859_ net17 _00664_ VSS VSS VDD VDD _03200_ sky130_fd_sc_hd__nor2_1
X_08860_ net159 _02011_ net164 _03200_ VSS VSS VDD VDD _00096_
+ sky130_fd_sc_hd__a211oi_1
Xinput13 a_left[6] VSS VSS VDD VDD net13 sky130_fd_sc_hd__clkdlybuf4s50_1
X_08862_ wrapped_design.a00_right\[6\] VSS VSS VDD VDD _03203_
+ sky130_fd_sc_hd__inv_1
X_08863_ net13 net159 net160 VSS VSS VDD VDD _03204_ sky130_fd_sc_hd__o21ai_0
X_08864_ net159 _03203_ _03204_ VSS VSS VDD VDD _00097_ sky130_fd_sc_hd__a21oi_1
Xinput12 a_left[5] VSS VSS VDD VDD net12 sky130_fd_sc_hd__clkdlybuf4s50_1
X_08866_ net163 wrapped_design.a00_right\[5\] net160 VSS VSS
+ VDD VDD _03206_ sky130_fd_sc_hd__o21ai_0
X_08867_ net163 _01337_ _03206_ VSS VSS VDD VDD _00098_ sky130_fd_sc_hd__a21oi_1
Xinput11 a_left[4] VSS VSS VDD VDD net11 sky130_fd_sc_hd__clkdlybuf4s50_1
X_08869_ net163 wrapped_design.a00_right\[4\] net160 VSS VSS
+ VDD VDD _03208_ sky130_fd_sc_hd__o21ai_0
X_08870_ net163 _01249_ _03208_ VSS VSS VDD VDD _00099_ sky130_fd_sc_hd__a21oi_1
Xinput10 a_left[3] VSS VSS VDD VDD net10 sky130_fd_sc_hd__clkdlybuf4s50_1
X_08872_ net163 wrapped_design.a00_right\[3\] net161 VSS VSS
+ VDD VDD _03211_ sky130_fd_sc_hd__o21ai_0
X_08873_ net163 _01200_ _03211_ VSS VSS VDD VDD _00100_ sky130_fd_sc_hd__a21oi_1
Xinput9 a_left[2] VSS VSS VDD VDD net9 sky130_fd_sc_hd__clkdlybuf4s50_1
Xinput8 a_left[1] VSS VSS VDD VDD net8 sky130_fd_sc_hd__clkdlybuf4s50_1
X_08876_ net163 wrapped_design.a00_right\[2\] net160 VSS VSS
+ VDD VDD _03214_ sky130_fd_sc_hd__o21ai_0
X_08877_ net163 _01024_ _03214_ VSS VSS VDD VDD _00101_ sky130_fd_sc_hd__a21oi_1
Xinput7 a_left[15] VSS VSS VDD VDD net7 sky130_fd_sc_hd__clkdlybuf4s50_1
X_08879_ net163 wrapped_design.a00_right\[1\] net160 VSS VSS
+ VDD VDD _03216_ sky130_fd_sc_hd__o21ai_0
X_08880_ net163 _01035_ _03216_ VSS VSS VDD VDD _00102_ sky130_fd_sc_hd__a21oi_1
Xinput6 a_left[14] VSS VSS VDD VDD net6 sky130_fd_sc_hd__clkdlybuf4s50_1
X_08882_ wrapped_design.a00_right\[0\] VSS VSS VDD VDD _03219_
+ sky130_fd_sc_hd__inv_2
X_08883_ net1 _00664_ net161 VSS VSS VDD VDD _03220_ sky130_fd_sc_hd__o21ai_0
X_08884_ net159 _03219_ _03220_ VSS VSS VDD VDD _00103_ sky130_fd_sc_hd__a21oi_1
X_08885_ wrapped_design.b1_skew\[6\] net153 VSS VSS VDD VDD
+ _03221_ sky130_fd_sc_hd__nor2_1
X_08886_ net156 wrapped_design.b01_down\[6\] net160 VSS VSS
+ VDD VDD _03222_ sky130_fd_sc_hd__o21ai_0
X_08887_ _03221_ _03222_ VSS VSS VDD VDD _00104_ sky130_fd_sc_hd__nor2_1
X_08888_ wrapped_design.b1_skew\[5\] net153 VSS VSS VDD VDD
+ _03223_ sky130_fd_sc_hd__nor2_1
X_08889_ net156 wrapped_design.b01_down\[5\] net160 VSS VSS
+ VDD VDD _03224_ sky130_fd_sc_hd__o21ai_0
X_08890_ _03223_ _03224_ VSS VSS VDD VDD _00105_ sky130_fd_sc_hd__nor2_1
X_08891_ net156 wrapped_design.b01_down\[4\] net160 VSS VSS
+ VDD VDD _03226_ sky130_fd_sc_hd__o21ai_0
X_08892_ net156 _00700_ _03226_ VSS VSS VDD VDD _00106_ sky130_fd_sc_hd__a21oi_1
X_08893_ wrapped_design.b1_skew\[3\] net153 VSS VSS VDD VDD
+ _03227_ sky130_fd_sc_hd__nor2_1
X_08894_ net156 wrapped_design.b01_down\[3\] net160 VSS VSS
+ VDD VDD _03228_ sky130_fd_sc_hd__o21ai_0
X_08895_ _03227_ _03228_ VSS VSS VDD VDD _00107_ sky130_fd_sc_hd__nor2_1
X_08896_ wrapped_design.b1_skew\[2\] net153 VSS VSS VDD VDD
+ _03229_ sky130_fd_sc_hd__nor2_1
X_08897_ net156 wrapped_design.b01_down\[2\] net160 VSS VSS
+ VDD VDD _03230_ sky130_fd_sc_hd__o21ai_0
X_08898_ _03229_ _03230_ VSS VSS VDD VDD _00108_ sky130_fd_sc_hd__nor2_1
X_08899_ wrapped_design.b1_skew\[1\] net153 VSS VSS VDD VDD
+ _03231_ sky130_fd_sc_hd__nor2_1
X_08900_ net156 wrapped_design.b01_down\[1\] net160 VSS VSS
+ VDD VDD _03232_ sky130_fd_sc_hd__o21ai_0
X_08901_ _03231_ _03232_ VSS VSS VDD VDD _00109_ sky130_fd_sc_hd__nor2_1
X_08902_ net156 wrapped_design.b01_down\[0\] net160 VSS VSS
+ VDD VDD _03234_ sky130_fd_sc_hd__o21ai_0
X_08903_ net156 _00713_ _03234_ VSS VSS VDD VDD _00110_ sky130_fd_sc_hd__a21oi_1
X_08904_ wrapped_design.b1_skew\[7\] VSS VSS VDD VDD _03235_
+ sky130_fd_sc_hd__inv_2
Xinput5 a_left[13] VSS VSS VDD VDD net5 sky130_fd_sc_hd__clkdlybuf4s50_1
X_08906_ wrapped_design.a00_right\[0\] _03235_ VSS VSS VDD
+ VDD _03237_ sky130_fd_sc_hd__nor2_1
X_08907_ wrapped_design.b1_skew\[6\] wrapped_design.a00_right\[1\]
+ VSS VSS VDD VDD _03238_ sky130_fd_sc_hd__nand2_1
X_08908_ _03237_ _03238_ VSS VSS VDD VDD _03239_ sky130_fd_sc_hd__nand2_1
X_08909_ _03238_ VSS VSS VDD VDD _03240_ sky130_fd_sc_hd__inv_1
Xinput4 a_left[12] VSS VSS VDD VDD net4 sky130_fd_sc_hd__clkdlybuf4s50_1
X_08911_ _03219_ wrapped_design.b1_skew\[7\] VSS VSS VDD VDD
+ _03243_ sky130_fd_sc_hd__nand2_1
X_08912_ _03240_ _03243_ VSS VSS VDD VDD _03244_ sky130_fd_sc_hd__nand2_1
X_08913_ wrapped_design.b1_skew\[5\] wrapped_design.a00_right\[2\]
+ VSS VSS VDD VDD _03245_ sky130_fd_sc_hd__nand2_1
X_08914_ _03239_ _03244_ _03245_ VSS VSS VDD VDD _03246_ sky130_fd_sc_hd__nand3_1
X_08915_ _03237_ _03240_ VSS VSS VDD VDD _03247_ sky130_fd_sc_hd__nand2_1
X_08916_ _03243_ _03238_ VSS VSS VDD VDD _03248_ sky130_fd_sc_hd__nand2_2
X_08917_ _03245_ VSS VSS VDD VDD _03249_ sky130_fd_sc_hd__inv_1
X_08918_ _03247_ _03248_ _03249_ VSS VSS VDD VDD _03250_ sky130_fd_sc_hd__nand3_1
X_08919_ wrapped_design.b1_skew\[5\] wrapped_design.a00_right\[0\]
+ VSS VSS VDD VDD _03251_ sky130_fd_sc_hd__nand2_1
X_08920_ _03238_ _03251_ VSS VSS VDD VDD _03252_ sky130_fd_sc_hd__nor2_2
X_08921_ _03246_ _03250_ _03252_ VSS VSS VDD VDD _03254_ sky130_fd_sc_hd__nand3_1
X_08922_ _03239_ _03244_ _03249_ VSS VSS VDD VDD _03255_ sky130_fd_sc_hd__nand3_1
X_08923_ _03247_ _03248_ _03245_ VSS VSS VDD VDD _03256_ sky130_fd_sc_hd__nand3_1
X_08924_ _03252_ VSS VSS VDD VDD _03257_ sky130_fd_sc_hd__inv_2
X_08925_ _03255_ _03256_ _03257_ VSS VSS VDD VDD _03258_ sky130_fd_sc_hd__nand3_1
X_08926_ wrapped_design.b1_skew\[4\] wrapped_design.a00_right\[4\]
+ VSS VSS VDD VDD _03259_ sky130_fd_sc_hd__nand2_1
X_08927_ wrapped_design.b1_skew\[3\] wrapped_design.a00_right\[3\]
+ VSS VSS VDD VDD _03260_ sky130_fd_sc_hd__nand2_2
X_08928_ _03259_ _03260_ VSS VSS VDD VDD _03261_ sky130_fd_sc_hd__nor2_1
X_08929_ wrapped_design.b1_skew\[3\] wrapped_design.a00_right\[4\]
+ VSS VSS VDD VDD _03262_ sky130_fd_sc_hd__nand2_1
X_08930_ wrapped_design.b1_skew\[4\] wrapped_design.a00_right\[3\]
+ VSS VSS VDD VDD _03263_ sky130_fd_sc_hd__nand2_1
X_08931_ _03262_ _03263_ VSS VSS VDD VDD _03265_ sky130_fd_sc_hd__nand2_2
X_08932_ _03265_ VSS VSS VDD VDD _03266_ sky130_fd_sc_hd__inv_1
X_08933_ _03261_ _03266_ VSS VSS VDD VDD _03267_ sky130_fd_sc_hd__nor2_1
X_08934_ wrapped_design.b1_skew\[2\] wrapped_design.a00_right\[5\]
+ VSS VSS VDD VDD _03268_ sky130_fd_sc_hd__nand2_1
X_08935_ _03267_ _03268_ VSS VSS VDD VDD _03269_ sky130_fd_sc_hd__nand2_1
X_08936_ _03259_ _03260_ _03265_ VSS VSS VDD VDD _03270_ sky130_fd_sc_hd__o21ai_0
X_08937_ _03268_ VSS VSS VDD VDD _03271_ sky130_fd_sc_hd__inv_1
X_08938_ _03270_ _03271_ VSS VSS VDD VDD _03272_ sky130_fd_sc_hd__nand2_1
X_08939_ _03269_ _03272_ VSS VSS VDD VDD _03273_ sky130_fd_sc_hd__nand2_1
X_08940_ _03254_ _03258_ _03273_ VSS VSS VDD VDD _03274_ sky130_fd_sc_hd__nand3_2
X_08941_ _03246_ _03250_ VSS VSS VDD VDD _03276_ sky130_fd_sc_hd__nand2_1
X_08942_ _03276_ _03252_ VSS VSS VDD VDD _03277_ sky130_fd_sc_hd__nand2_1
X_08943_ _03246_ _03250_ _03257_ VSS VSS VDD VDD _03278_ sky130_fd_sc_hd__nand3_1
X_08944_ _03267_ _03271_ VSS VSS VDD VDD _03279_ sky130_fd_sc_hd__nand2_1
X_08945_ _03270_ _03268_ VSS VSS VDD VDD _03280_ sky130_fd_sc_hd__nand2_1
X_08946_ _03279_ _03280_ VSS VSS VDD VDD _03281_ sky130_fd_sc_hd__nand2_1
X_08947_ _03277_ _03278_ _03281_ VSS VSS VDD VDD _03282_ sky130_fd_sc_hd__nand3_1
X_08948_ _03274_ _03282_ VSS VSS VDD VDD _03283_ sky130_fd_sc_hd__nand2_2
X_08949_ wrapped_design.b1_skew\[3\] wrapped_design.b1_skew\[4\]
+ wrapped_design.a00_right\[2\] wrapped_design.a00_right\[3\]
+ VSS VSS VDD VDD _03284_ sky130_fd_sc_hd__nand4_1
X_08950_ wrapped_design.b1_skew\[4\] wrapped_design.a00_right\[2\]
+ VSS VSS VDD VDD _03285_ sky130_fd_sc_hd__nand2_1
X_08951_ _03260_ _03285_ VSS VSS VDD VDD _03287_ sky130_fd_sc_hd__nand2_1
X_08952_ _03284_ _03287_ VSS VSS VDD VDD _03288_ sky130_fd_sc_hd__nand2_1
X_08953_ wrapped_design.b1_skew\[2\] wrapped_design.a00_right\[4\]
+ VSS VSS VDD VDD _03289_ sky130_fd_sc_hd__nand2_1
X_08954_ _03288_ _03289_ VSS VSS VDD VDD _03290_ sky130_fd_sc_hd__nand2_1
X_08955_ wrapped_design.b1_skew\[5\] wrapped_design.a00_right\[1\]
+ VSS VSS VDD VDD _03291_ sky130_fd_sc_hd__nand2_1
X_08956_ wrapped_design.b1_skew\[6\] wrapped_design.a00_right\[0\]
+ VSS VSS VDD VDD _03292_ sky130_fd_sc_hd__nand2_1
X_08957_ _03291_ _03292_ VSS VSS VDD VDD _03293_ sky130_fd_sc_hd__nand2_1
X_08958_ _03257_ _03293_ VSS VSS VDD VDD _03294_ sky130_fd_sc_hd__nand2_2
X_08959_ _03294_ VSS VSS VDD VDD _03295_ sky130_fd_sc_hd__inv_1
X_08960_ _03289_ VSS VSS VDD VDD _03296_ sky130_fd_sc_hd__inv_1
X_08961_ _03284_ _03296_ _03287_ VSS VSS VDD VDD _03298_ sky130_fd_sc_hd__nand3_1
X_08962_ _03290_ _03295_ _03298_ VSS VSS VDD VDD _03299_ sky130_fd_sc_hd__nand3_2
X_08963_ _03283_ _03299_ VSS VSS VDD VDD _03300_ sky130_fd_sc_hd__nand2_2
X_08964_ _03299_ VSS VSS VDD VDD _03301_ sky130_fd_sc_hd__inv_1
X_08965_ _03274_ _03282_ _03301_ VSS VSS VDD VDD _03302_ sky130_fd_sc_hd__nand3_1
Xinput3 a_left[11] VSS VSS VDD VDD net3 sky130_fd_sc_hd__clkdlybuf4s50_1
X_08967_ wrapped_design.a00_right\[7\] wrapped_design.b1_skew\[0\]
+ VSS VSS VDD VDD _03304_ sky130_fd_sc_hd__nand2_1
X_08968_ wrapped_design.b1_skew\[1\] wrapped_design.a00_right\[6\]
+ VSS VSS VDD VDD _03305_ sky130_fd_sc_hd__nand2_1
X_08969_ _03304_ _03305_ VSS VSS VDD VDD _03306_ sky130_fd_sc_hd__nor2_1
X_08970_ _03304_ _03305_ VSS VSS VDD VDD _03307_ sky130_fd_sc_hd__nand2_1
X_08971_ _03307_ VSS VSS VDD VDD _03309_ sky130_fd_sc_hd__inv_1
X_08972_ _03306_ _03309_ VSS VSS VDD VDD _03310_ sky130_fd_sc_hd__nor2_1
X_08973_ _03310_ _03235_ VSS VSS VDD VDD _03311_ sky130_fd_sc_hd__nand2_1
X_08974_ wrapped_design.a00_right\[7\] wrapped_design.b1_skew\[1\]
+ VSS VSS VDD VDD _03312_ sky130_fd_sc_hd__nand2_1
X_08975_ wrapped_design.b1_skew\[0\] wrapped_design.a00_right\[6\]
+ VSS VSS VDD VDD _03313_ sky130_fd_sc_hd__nand2_1
X_08976_ _03312_ _03313_ _03307_ VSS VSS VDD VDD _03314_ sky130_fd_sc_hd__o21ai_0
X_08977_ _03314_ wrapped_design.b1_skew\[7\] VSS VSS VDD VDD
+ _03315_ sky130_fd_sc_hd__nand2_1
X_08978_ _03311_ _03315_ VSS VSS VDD VDD _03316_ sky130_fd_sc_hd__nand2_1
X_08979_ _03296_ _03287_ _03284_ VSS VSS VDD VDD _03317_ sky130_fd_sc_hd__a21boi_0
X_08980_ _03316_ _03317_ VSS VSS VDD VDD _03318_ sky130_fd_sc_hd__nand2_1
X_08981_ _03310_ wrapped_design.b1_skew\[7\] VSS VSS VDD VDD
+ _03320_ sky130_fd_sc_hd__nand2_1
X_08982_ _03314_ _03235_ VSS VSS VDD VDD _03321_ sky130_fd_sc_hd__nand2_1
X_08983_ _03320_ _03321_ VSS VSS VDD VDD _03322_ sky130_fd_sc_hd__nand2_1
X_08984_ _03298_ _03284_ VSS VSS VDD VDD _03323_ sky130_fd_sc_hd__nand2_1
X_08985_ _03322_ _03323_ VSS VSS VDD VDD _03324_ sky130_fd_sc_hd__nand2_1
X_08986_ wrapped_design.b1_skew\[1\] wrapped_design.a00_right\[5\]
+ VSS VSS VDD VDD _03325_ sky130_fd_sc_hd__nand2_2
X_08987_ _03325_ VSS VSS VDD VDD _03326_ sky130_fd_sc_hd__inv_1
X_08988_ _03326_ wrapped_design.b1_skew\[0\] wrapped_design.a00_right\[6\]
+ VSS VSS VDD VDD _03327_ sky130_fd_sc_hd__nand3_1
X_08989_ _03327_ VSS VSS VDD VDD _03328_ sky130_fd_sc_hd__inv_1
X_08990_ _03318_ _03324_ _03328_ VSS VSS VDD VDD _03329_ sky130_fd_sc_hd__nand3_1
X_08991_ _03322_ _03317_ VSS VSS VDD VDD _03331_ sky130_fd_sc_hd__nand2_1
X_08992_ _03316_ _03323_ VSS VSS VDD VDD _03332_ sky130_fd_sc_hd__nand2_1
X_08993_ _03331_ _03332_ _03327_ VSS VSS VDD VDD _03333_ sky130_fd_sc_hd__nand3_1
X_08994_ _03329_ _03333_ VSS VSS VDD VDD _03334_ sky130_fd_sc_hd__nand2_1
X_08995_ _03300_ _03302_ _03334_ VSS VSS VDD VDD _03335_ sky130_fd_sc_hd__nand3_1
X_08996_ _03283_ _03301_ VSS VSS VDD VDD _03336_ sky130_fd_sc_hd__nand2_1
X_08997_ _03274_ _03282_ _03299_ VSS VSS VDD VDD _03337_ sky130_fd_sc_hd__nand3_1
X_08998_ _03331_ _03332_ _03328_ VSS VSS VDD VDD _03338_ sky130_fd_sc_hd__nand3_1
X_08999_ _03318_ _03324_ _03327_ VSS VSS VDD VDD _03339_ sky130_fd_sc_hd__nand3_1
X_09000_ _03338_ _03339_ VSS VSS VDD VDD _03340_ sky130_fd_sc_hd__nand2_1
X_09001_ _03336_ _03337_ _03340_ VSS VSS VDD VDD _03342_ sky130_fd_sc_hd__nand3_1
X_09002_ _03335_ _03342_ VSS VSS VDD VDD _03343_ sky130_fd_sc_hd__nand2_1
X_09003_ _03313_ _03325_ VSS VSS VDD VDD _03344_ sky130_fd_sc_hd__nand2_1
X_09004_ _03327_ _03344_ VSS VSS VDD VDD _03345_ sky130_fd_sc_hd__nand2_1
X_09005_ wrapped_design.b1_skew\[3\] wrapped_design.a00_right\[2\]
+ VSS VSS VDD VDD _03346_ sky130_fd_sc_hd__nand2_1
X_09006_ wrapped_design.b1_skew\[4\] wrapped_design.a00_right\[1\]
+ VSS VSS VDD VDD _03347_ sky130_fd_sc_hd__nand2_1
X_09007_ _03346_ _03347_ VSS VSS VDD VDD _03348_ sky130_fd_sc_hd__nand2_1
X_09008_ wrapped_design.b1_skew\[2\] wrapped_design.a00_right\[3\]
+ VSS VSS VDD VDD _03349_ sky130_fd_sc_hd__nand2_1
X_09009_ _03349_ VSS VSS VDD VDD _03350_ sky130_fd_sc_hd__inv_1
X_09010_ wrapped_design.b1_skew\[3\] wrapped_design.a00_right\[1\]
+ VSS VSS VDD VDD _03351_ sky130_fd_sc_hd__nand2_2
X_09011_ _03285_ _03351_ VSS VSS VDD VDD _03353_ sky130_fd_sc_hd__nor2_1
X_09012_ _03348_ _03350_ _03353_ VSS VSS VDD VDD _03354_ sky130_fd_sc_hd__a21oi_1
X_09013_ _03345_ _03354_ VSS VSS VDD VDD _03355_ sky130_fd_sc_hd__nor2_1
X_09014_ _03354_ _03345_ VSS VSS VDD VDD _03356_ sky130_fd_sc_hd__nand2_1
X_09015_ _03356_ VSS VSS VDD VDD _03357_ sky130_fd_sc_hd__inv_1
X_09016_ wrapped_design.b1_skew\[0\] wrapped_design.a00_right\[4\]
+ VSS VSS VDD VDD _03358_ sky130_fd_sc_hd__nand2_1
X_09017_ _03325_ _03358_ VSS VSS VDD VDD _03359_ sky130_fd_sc_hd__nor2_1
X_09018_ _03355_ _03357_ _03359_ VSS VSS VDD VDD _03360_ sky130_fd_sc_hd__o21ai_0
X_09019_ _03355_ _03357_ VSS VSS VDD VDD _03361_ sky130_fd_sc_hd__nor2_1
X_09020_ _03359_ VSS VSS VDD VDD _03362_ sky130_fd_sc_hd__inv_2
X_09021_ _03361_ _03362_ VSS VSS VDD VDD _03364_ sky130_fd_sc_hd__nand2_1
X_09022_ _03360_ _03364_ VSS VSS VDD VDD _03365_ sky130_fd_sc_hd__nand2_1
X_09023_ _03290_ _03298_ VSS VSS VDD VDD _03366_ sky130_fd_sc_hd__nand2_1
X_09024_ _03366_ _03294_ VSS VSS VDD VDD _03367_ sky130_fd_sc_hd__nand2_1
X_09025_ _03367_ _03299_ VSS VSS VDD VDD _03368_ sky130_fd_sc_hd__nand2_1
X_09026_ _03353_ VSS VSS VDD VDD _03369_ sky130_fd_sc_hd__inv_1
X_09027_ _03369_ _03348_ VSS VSS VDD VDD _03370_ sky130_fd_sc_hd__nand2_1
X_09028_ _03370_ _03349_ VSS VSS VDD VDD _03371_ sky130_fd_sc_hd__nand2_1
X_09029_ _03369_ _03350_ _03348_ VSS VSS VDD VDD _03372_ sky130_fd_sc_hd__nand3_1
X_09030_ _03251_ _03371_ _03372_ VSS VSS VDD VDD _03373_ sky130_fd_sc_hd__nand3b_1
X_09031_ _03368_ _03373_ VSS VSS VDD VDD _03375_ sky130_fd_sc_hd__nand2_1
X_09032_ _03366_ _03295_ VSS VSS VDD VDD _03376_ sky130_fd_sc_hd__nand2_1
X_09033_ _03290_ _03298_ _03294_ VSS VSS VDD VDD _03377_ sky130_fd_sc_hd__nand3_1
X_09034_ _03376_ _03377_ VSS VSS VDD VDD _03378_ sky130_fd_sc_hd__nand2_1
X_09035_ _03373_ VSS VSS VDD VDD _03379_ sky130_fd_sc_hd__inv_1
X_09036_ _03378_ _03379_ VSS VSS VDD VDD _03380_ sky130_fd_sc_hd__nand2_1
X_09037_ _03365_ _03375_ _03380_ VSS VSS VDD VDD _03381_ sky130_fd_sc_hd__a21boi_0
X_09038_ _03343_ _03381_ VSS VSS VDD VDD _03382_ sky130_fd_sc_hd__nand2_1
X_09039_ _03368_ _03379_ VSS VSS VDD VDD _03383_ sky130_fd_sc_hd__nand2_1
X_09040_ _03378_ _03373_ VSS VSS VDD VDD _03384_ sky130_fd_sc_hd__nand2_1
X_09041_ _03383_ _03384_ VSS VSS VDD VDD _03386_ sky130_fd_sc_hd__nand2_1
X_09042_ _03386_ _03365_ VSS VSS VDD VDD _03387_ sky130_fd_sc_hd__nand2_1
X_09043_ _03387_ _03380_ VSS VSS VDD VDD _03388_ sky130_fd_sc_hd__nand2_1
X_09044_ _03335_ _03342_ _03388_ VSS VSS VDD VDD _03389_ sky130_fd_sc_hd__nand3_1
X_09045_ _03356_ _03359_ _03355_ VSS VSS VDD VDD _03390_ sky130_fd_sc_hd__a21oi_1
X_09046_ _03390_ VSS VSS VDD VDD _03391_ sky130_fd_sc_hd__inv_1
X_09047_ _03382_ _03389_ _03391_ VSS VSS VDD VDD _03392_ sky130_fd_sc_hd__nand3_1
X_09048_ _03343_ _03388_ VSS VSS VDD VDD _03393_ sky130_fd_sc_hd__nand2_1
X_09049_ _03335_ _03342_ _03381_ VSS VSS VDD VDD _03394_ sky130_fd_sc_hd__nand3_1
X_09050_ _03393_ _03394_ _03390_ VSS VSS VDD VDD _03395_ sky130_fd_sc_hd__nand3_1
X_09051_ _03392_ _03395_ VSS VSS VDD VDD _03397_ sky130_fd_sc_hd__nand2_1
X_09052_ _03380_ _03375_ VSS VSS VDD VDD _03398_ sky130_fd_sc_hd__nand2_1
X_09053_ _03355_ _03357_ _03362_ VSS VSS VDD VDD _03399_ sky130_fd_sc_hd__o21ai_0
X_09054_ _03361_ _03359_ VSS VSS VDD VDD _03400_ sky130_fd_sc_hd__nand2_1
X_09055_ _03399_ _03400_ VSS VSS VDD VDD _03401_ sky130_fd_sc_hd__nand2_1
X_09056_ _03398_ _03401_ VSS VSS VDD VDD _03402_ sky130_fd_sc_hd__nand2_1
X_09057_ _03387_ _03402_ VSS VSS VDD VDD _03403_ sky130_fd_sc_hd__nand2_1
X_09058_ _03371_ _03372_ VSS VSS VDD VDD _03404_ sky130_fd_sc_hd__nand2_1
X_09059_ _03404_ _03251_ VSS VSS VDD VDD _03405_ sky130_fd_sc_hd__nand2_1
X_09060_ _03405_ _03373_ VSS VSS VDD VDD _03406_ sky130_fd_sc_hd__nand2_1
X_09061_ _03406_ VSS VSS VDD VDD _03408_ sky130_fd_sc_hd__inv_2
X_09062_ wrapped_design.b1_skew\[4\] wrapped_design.a00_right\[0\]
+ VSS VSS VDD VDD _03409_ sky130_fd_sc_hd__nand2_1
X_09063_ _03351_ _03409_ VSS VSS VDD VDD _03410_ sky130_fd_sc_hd__nand2_1
X_09064_ wrapped_design.b1_skew\[2\] wrapped_design.a00_right\[2\]
+ VSS VSS VDD VDD _03411_ sky130_fd_sc_hd__nand2_1
X_09065_ _03411_ VSS VSS VDD VDD _03412_ sky130_fd_sc_hd__inv_1
X_09066_ wrapped_design.b1_skew\[3\] wrapped_design.a00_right\[0\]
+ VSS VSS VDD VDD _03413_ sky130_fd_sc_hd__nand2_1
X_09067_ _03347_ _03413_ VSS VSS VDD VDD _03414_ sky130_fd_sc_hd__nor2_1
X_09068_ _03410_ _03412_ _03414_ VSS VSS VDD VDD _03415_ sky130_fd_sc_hd__a21oi_1
X_09069_ _03415_ VSS VSS VDD VDD _03416_ sky130_fd_sc_hd__inv_1
X_09070_ wrapped_design.b1_skew\[0\] wrapped_design.a00_right\[5\]
+ VSS VSS VDD VDD _03417_ sky130_fd_sc_hd__nand2_1
X_09071_ wrapped_design.b1_skew\[1\] wrapped_design.a00_right\[4\]
+ VSS VSS VDD VDD _03419_ sky130_fd_sc_hd__nand2_1
X_09072_ _03417_ _03419_ VSS VSS VDD VDD _03420_ sky130_fd_sc_hd__nand2_1
X_09073_ _03362_ _03420_ VSS VSS VDD VDD _03421_ sky130_fd_sc_hd__nand2_1
X_09074_ _03421_ VSS VSS VDD VDD _03422_ sky130_fd_sc_hd__inv_1
X_09075_ _03416_ _03422_ VSS VSS VDD VDD _03423_ sky130_fd_sc_hd__nand2_1
X_09076_ wrapped_design.b1_skew\[0\] wrapped_design.a00_right\[3\]
+ VSS VSS VDD VDD _03424_ sky130_fd_sc_hd__nand2_1
X_09077_ _03419_ _03424_ VSS VSS VDD VDD _03425_ sky130_fd_sc_hd__nor2_1
X_09078_ _03415_ _03421_ VSS VSS VDD VDD _03426_ sky130_fd_sc_hd__nand2_1
X_09079_ _03423_ _03425_ _03426_ VSS VSS VDD VDD _03427_ sky130_fd_sc_hd__nand3_1
X_09080_ _03423_ _03426_ VSS VSS VDD VDD _03428_ sky130_fd_sc_hd__nand2_1
X_09081_ _03425_ VSS VSS VDD VDD _03430_ sky130_fd_sc_hd__inv_1
X_09082_ _03428_ _03430_ VSS VSS VDD VDD _03431_ sky130_fd_sc_hd__nand2_1
X_09083_ _03408_ _03427_ _03431_ VSS VSS VDD VDD _03432_ sky130_fd_sc_hd__nand3_2
X_09084_ _03403_ _03432_ VSS VSS VDD VDD _03433_ sky130_fd_sc_hd__nand2_1
X_09085_ _03432_ VSS VSS VDD VDD _03434_ sky130_fd_sc_hd__inv_1
X_09086_ _03387_ _03402_ _03434_ VSS VSS VDD VDD _03435_ sky130_fd_sc_hd__nand3_1
X_09087_ _03427_ _03423_ VSS VSS VDD VDD _03436_ sky130_fd_sc_hd__nand2_1
X_09088_ _03433_ _03435_ _03436_ VSS VSS VDD VDD _03437_ sky130_fd_sc_hd__nand3_1
X_09089_ _03437_ _03435_ VSS VSS VDD VDD _03438_ sky130_fd_sc_hd__nand2_1
X_09090_ _03397_ _03438_ VSS VSS VDD VDD _03439_ sky130_fd_sc_hd__nand2_1
X_09091_ _03436_ _03433_ _03435_ VSS VSS VDD VDD _03441_ sky130_fd_sc_hd__a21boi_1
X_09092_ _03392_ _03441_ _03395_ VSS VSS VDD VDD _03442_ sky130_fd_sc_hd__nand3_1
X_09093_ _03439_ _03442_ VSS VSS VDD VDD _03443_ sky130_fd_sc_hd__nand2_2
X_09094_ _03403_ _03434_ VSS VSS VDD VDD _03444_ sky130_fd_sc_hd__nand2_1
X_09095_ _03387_ _03402_ _03432_ VSS VSS VDD VDD _03445_ sky130_fd_sc_hd__nand3_1
X_09096_ _03436_ VSS VSS VDD VDD _03446_ sky130_fd_sc_hd__inv_1
X_09097_ _03444_ _03445_ _03446_ VSS VSS VDD VDD _03447_ sky130_fd_sc_hd__nand3_1
X_09098_ _03437_ _03447_ VSS VSS VDD VDD _03448_ sky130_fd_sc_hd__nand2_1
X_09099_ _03431_ _03427_ VSS VSS VDD VDD _03449_ sky130_fd_sc_hd__nand2_1
X_09100_ _03449_ _03406_ VSS VSS VDD VDD _03450_ sky130_fd_sc_hd__nand2_1
X_09101_ _03410_ VSS VSS VDD VDD _03452_ sky130_fd_sc_hd__inv_1
X_09102_ _03414_ _03452_ VSS VSS VDD VDD _03453_ sky130_fd_sc_hd__nor2_1
X_09103_ _03411_ _03453_ VSS VSS VDD VDD _03454_ sky130_fd_sc_hd__xor2_1
X_09104_ wrapped_design.b1_skew\[1\] wrapped_design.a00_right\[3\]
+ VSS VSS VDD VDD _03455_ sky130_fd_sc_hd__nand2_1
X_09105_ _03358_ _03455_ VSS VSS VDD VDD _03456_ sky130_fd_sc_hd__nand2_1
X_09106_ _03430_ _03456_ VSS VSS VDD VDD _03457_ sky130_fd_sc_hd__nand2_1
X_09107_ wrapped_design.b1_skew\[2\] wrapped_design.a00_right\[0\]
+ VSS VSS VDD VDD _03458_ sky130_fd_sc_hd__nand2_1
X_09108_ _03351_ _03458_ VSS VSS VDD VDD _03459_ sky130_fd_sc_hd__nor2_1
X_09109_ _03459_ VSS VSS VDD VDD _03460_ sky130_fd_sc_hd__inv_1
X_09110_ _03457_ _03460_ VSS VSS VDD VDD _03461_ sky130_fd_sc_hd__nand2_1
X_09111_ _03430_ _03459_ _03456_ VSS VSS VDD VDD _03463_ sky130_fd_sc_hd__nand3_1
X_09112_ _03461_ _03463_ VSS VSS VDD VDD _03464_ sky130_fd_sc_hd__nand2_1
X_09113_ wrapped_design.b1_skew\[0\] wrapped_design.a00_right\[2\]
+ VSS VSS VDD VDD _03465_ sky130_fd_sc_hd__nand2_2
X_09114_ _03465_ VSS VSS VDD VDD _03466_ sky130_fd_sc_hd__inv_1
X_09115_ _03466_ wrapped_design.b1_skew\[1\] wrapped_design.a00_right\[3\]
+ VSS VSS VDD VDD _03467_ sky130_fd_sc_hd__nand3_1
X_09116_ _03464_ _03467_ VSS VSS VDD VDD _03468_ sky130_fd_sc_hd__nand2_1
X_09117_ _03467_ _03461_ _03463_ VSS VSS VDD VDD _03469_ sky130_fd_sc_hd__nand3b_1
X_09118_ _03468_ _03469_ VSS VSS VDD VDD _03470_ sky130_fd_sc_hd__nand2_1
X_09119_ _03454_ _03470_ VSS VSS VDD VDD _03471_ sky130_fd_sc_hd__nor2_1
X_09120_ _03432_ _03450_ _03471_ VSS VSS VDD VDD _03472_ sky130_fd_sc_hd__nand3_1
X_09121_ _03449_ _03408_ VSS VSS VDD VDD _03474_ sky130_fd_sc_hd__nand2_1
X_09122_ _03431_ _03406_ _03427_ VSS VSS VDD VDD _03475_ sky130_fd_sc_hd__nand3_1
X_09123_ _03471_ VSS VSS VDD VDD _03476_ sky130_fd_sc_hd__inv_1
X_09124_ _03474_ _03475_ _03476_ VSS VSS VDD VDD _03477_ sky130_fd_sc_hd__nand3_1
X_09125_ _03469_ _03463_ VSS VSS VDD VDD _03478_ sky130_fd_sc_hd__nand2_1
X_09126_ _03472_ _03477_ _03478_ VSS VSS VDD VDD _03479_ sky130_fd_sc_hd__nand3_1
X_09127_ _03479_ _03472_ VSS VSS VDD VDD _03480_ sky130_fd_sc_hd__nand2_1
X_09128_ _03448_ _03480_ VSS VSS VDD VDD _03481_ sky130_fd_sc_hd__nand2_1
X_09129_ _03433_ _03435_ _03446_ VSS VSS VDD VDD _03482_ sky130_fd_sc_hd__nand3_1
X_09130_ _03444_ _03445_ _03436_ VSS VSS VDD VDD _03483_ sky130_fd_sc_hd__nand3_1
X_09131_ _03482_ _03483_ VSS VSS VDD VDD _03485_ sky130_fd_sc_hd__nand2_1
X_09132_ _03480_ VSS VSS VDD VDD _03486_ sky130_fd_sc_hd__inv_1
X_09133_ _03485_ _03486_ VSS VSS VDD VDD _03487_ sky130_fd_sc_hd__nand2_1
X_09134_ _03481_ _03487_ VSS VSS VDD VDD _03488_ sky130_fd_sc_hd__nand2_1
X_09135_ _03478_ VSS VSS VDD VDD _03489_ sky130_fd_sc_hd__inv_1
X_09136_ _03472_ _03477_ _03489_ VSS VSS VDD VDD _03490_ sky130_fd_sc_hd__nand3_1
X_09137_ _03432_ _03450_ _03476_ VSS VSS VDD VDD _03491_ sky130_fd_sc_hd__nand3_1
X_09138_ _03474_ _03475_ _03471_ VSS VSS VDD VDD _03492_ sky130_fd_sc_hd__nand3_1
X_09139_ _03491_ _03492_ _03478_ VSS VSS VDD VDD _03493_ sky130_fd_sc_hd__nand3_1
X_09140_ _03490_ _03493_ VSS VSS VDD VDD _03494_ sky130_fd_sc_hd__nand2_1
X_09141_ _03470_ _03454_ VSS VSS VDD VDD _03496_ sky130_fd_sc_hd__nand2_1
X_09142_ wrapped_design.b1_skew\[2\] wrapped_design.a00_right\[1\]
+ VSS VSS VDD VDD _03497_ sky130_fd_sc_hd__nand2_1
X_09143_ _03413_ _03497_ VSS VSS VDD VDD _03498_ sky130_fd_sc_hd__nand2_1
X_09144_ _03460_ _03498_ VSS VSS VDD VDD _03499_ sky130_fd_sc_hd__nand2_1
X_09145_ wrapped_design.b1_skew\[1\] wrapped_design.a00_right\[2\]
+ VSS VSS VDD VDD _03500_ sky130_fd_sc_hd__nand2_1
X_09146_ _03424_ _03500_ VSS VSS VDD VDD _03501_ sky130_fd_sc_hd__nand2_1
X_09147_ _03467_ _03501_ VSS VSS VDD VDD _03502_ sky130_fd_sc_hd__nand2_1
X_09148_ wrapped_design.b1_skew\[1\] wrapped_design.a00_right\[1\]
+ VSS VSS VDD VDD _03503_ sky130_fd_sc_hd__nand2_1
X_09149_ _03503_ VSS VSS VDD VDD _03504_ sky130_fd_sc_hd__inv_1
X_09150_ _03466_ _03504_ VSS VSS VDD VDD _03505_ sky130_fd_sc_hd__nand2_1
X_09151_ _03502_ _03505_ VSS VSS VDD VDD _03507_ sky130_fd_sc_hd__nand2_1
X_09152_ _03501_ _03466_ _03504_ _03455_ VSS VSS VDD VDD _03508_
+ sky130_fd_sc_hd__nand4_1
X_09153_ _03507_ _03508_ VSS VSS VDD VDD _03509_ sky130_fd_sc_hd__nand2_1
X_09154_ _03499_ _03509_ _03508_ VSS VSS VDD VDD _03510_ sky130_fd_sc_hd__o21ai_0
X_09155_ _03476_ _03496_ _03510_ VSS VSS VDD VDD _03511_ sky130_fd_sc_hd__nand3_1
X_09156_ _03476_ _03496_ _03510_ VSS VSS VDD VDD _03512_ sky130_fd_sc_hd__a21o_1
X_09157_ _03499_ _03509_ VSS VSS VDD VDD _03513_ sky130_fd_sc_hd__xnor2_1
X_09158_ _03465_ _03503_ VSS VSS VDD VDD _03514_ sky130_fd_sc_hd__nand2_1
X_09159_ _03505_ _03514_ VSS VSS VDD VDD _03515_ sky130_fd_sc_hd__nand2_1
X_09160_ wrapped_design.b1_skew\[0\] wrapped_design.a00_right\[0\]
+ VSS VSS VDD VDD _03516_ sky130_fd_sc_hd__nand2_1
X_09161_ _03503_ _03516_ VSS VSS VDD VDD _03518_ sky130_fd_sc_hd__nor2_1
X_09162_ _03518_ VSS VSS VDD VDD _03519_ sky130_fd_sc_hd__inv_1
X_09163_ _03515_ _03519_ VSS VSS VDD VDD _03520_ sky130_fd_sc_hd__nand2_1
X_09164_ _03516_ VSS VSS VDD VDD _03521_ sky130_fd_sc_hd__inv_1
X_09165_ _03504_ _03521_ _03465_ VSS VSS VDD VDD _03522_ sky130_fd_sc_hd__nand3_1
X_09166_ _03520_ _03522_ VSS VSS VDD VDD _03523_ sky130_fd_sc_hd__nand2_1
X_09167_ _03458_ _03523_ VSS VSS VDD VDD _03524_ sky130_fd_sc_hd__nor2_1
X_09168_ _03524_ VSS VSS VDD VDD _03525_ sky130_fd_sc_hd__inv_1
X_09169_ _03525_ _03522_ VSS VSS VDD VDD _03526_ sky130_fd_sc_hd__nand2_1
X_09170_ _03513_ _03526_ VSS VSS VDD VDD _03527_ sky130_fd_sc_hd__nand2b_1
X_09171_ _03527_ VSS VSS VDD VDD _03529_ sky130_fd_sc_hd__inv_1
X_09172_ _03494_ _03511_ _03512_ _03529_ VSS VSS VDD VDD _03530_
+ sky130_fd_sc_hd__nand4_1
X_09173_ _03511_ VSS VSS VDD VDD _03531_ sky130_fd_sc_hd__inv_1
X_09174_ _03494_ _03531_ VSS VSS VDD VDD _03532_ sky130_fd_sc_hd__nand2_1
X_09175_ _03530_ _03532_ VSS VSS VDD VDD _03533_ sky130_fd_sc_hd__nand2_1
X_09176_ _03443_ _03488_ _03533_ VSS VSS VDD VDD _03534_ sky130_fd_sc_hd__nand3_1
X_09177_ _03397_ _03441_ VSS VSS VDD VDD _03535_ sky130_fd_sc_hd__nand2_1
X_09178_ _03485_ _03480_ VSS VSS VDD VDD _03536_ sky130_fd_sc_hd__nand2_2
X_09179_ _03536_ VSS VSS VDD VDD _03537_ sky130_fd_sc_hd__inv_1
X_09180_ _03392_ _03395_ _03438_ VSS VSS VDD VDD _03538_ sky130_fd_sc_hd__nand3_1
X_09181_ _03538_ VSS VSS VDD VDD _03540_ sky130_fd_sc_hd__inv_1
X_09182_ _03535_ _03537_ _03540_ VSS VSS VDD VDD _03541_ sky130_fd_sc_hd__a21oi_2
X_09183_ _03534_ _03541_ VSS VSS VDD VDD _03542_ sky130_fd_sc_hd__nand2_1
X_09184_ wrapped_design.a00_right\[1\] _03235_ VSS VSS VDD
+ VDD _03543_ sky130_fd_sc_hd__nor2_1
X_09185_ wrapped_design.b1_skew\[6\] wrapped_design.a00_right\[2\]
+ VSS VSS VDD VDD _03544_ sky130_fd_sc_hd__nand2_2
X_09186_ _03543_ _03544_ VSS VSS VDD VDD _03545_ sky130_fd_sc_hd__nand2_1
X_09187_ _03544_ VSS VSS VDD VDD _03546_ sky130_fd_sc_hd__inv_1
X_09188_ wrapped_design.a00_right\[1\] VSS VSS VDD VDD _03547_
+ sky130_fd_sc_hd__inv_1
X_09189_ _03547_ wrapped_design.b1_skew\[7\] VSS VSS VDD VDD
+ _03548_ sky130_fd_sc_hd__nand2_1
X_09190_ _03546_ _03548_ VSS VSS VDD VDD _03549_ sky130_fd_sc_hd__nand2_1
X_09191_ wrapped_design.b1_skew\[5\] wrapped_design.a00_right\[3\]
+ VSS VSS VDD VDD _03551_ sky130_fd_sc_hd__nand2_1
X_09192_ _03545_ _03549_ _03551_ VSS VSS VDD VDD _03552_ sky130_fd_sc_hd__nand3_1
X_09193_ _03543_ _03546_ VSS VSS VDD VDD _03553_ sky130_fd_sc_hd__nand2_1
X_09194_ _03548_ _03544_ VSS VSS VDD VDD _03554_ sky130_fd_sc_hd__nand2_1
X_09195_ _03551_ VSS VSS VDD VDD _03555_ sky130_fd_sc_hd__inv_2
X_09196_ _03553_ _03554_ _03555_ VSS VSS VDD VDD _03556_ sky130_fd_sc_hd__nand3_1
X_09197_ _03552_ _03556_ VSS VSS VDD VDD _03557_ sky130_fd_sc_hd__nand2_1
X_09198_ _03238_ _03243_ VSS VSS VDD VDD _03558_ sky130_fd_sc_hd__nor2_1
X_09199_ _03248_ _03249_ _03558_ VSS VSS VDD VDD _03559_ sky130_fd_sc_hd__a21oi_2
X_09200_ _03559_ VSS VSS VDD VDD _03560_ sky130_fd_sc_hd__inv_1
X_09201_ _03557_ _03560_ VSS VSS VDD VDD _03562_ sky130_fd_sc_hd__nand2_1
X_09202_ _03545_ _03549_ _03555_ VSS VSS VDD VDD _03563_ sky130_fd_sc_hd__nand3_1
X_09203_ _03553_ _03554_ _03551_ VSS VSS VDD VDD _03564_ sky130_fd_sc_hd__nand3_1
X_09204_ _03563_ _03564_ VSS VSS VDD VDD _03565_ sky130_fd_sc_hd__nand2_1
X_09205_ _03565_ _03559_ VSS VSS VDD VDD _03566_ sky130_fd_sc_hd__nand2_1
X_09206_ wrapped_design.b1_skew\[4\] wrapped_design.a00_right\[5\]
+ VSS VSS VDD VDD _03567_ sky130_fd_sc_hd__nand2_1
X_09207_ wrapped_design.b1_skew\[3\] wrapped_design.a00_right\[5\]
+ VSS VSS VDD VDD _03568_ sky130_fd_sc_hd__nand2_2
X_09208_ _03568_ _03259_ VSS VSS VDD VDD _03569_ sky130_fd_sc_hd__nand2_1
X_09209_ _03567_ _03262_ _03569_ VSS VSS VDD VDD _03570_ sky130_fd_sc_hd__o21ai_1
X_09210_ _03570_ VSS VSS VDD VDD _03571_ sky130_fd_sc_hd__inv_1
X_09211_ wrapped_design.b1_skew\[2\] wrapped_design.a00_right\[6\]
+ VSS VSS VDD VDD _03573_ sky130_fd_sc_hd__nand2_1
X_09212_ _03571_ _03573_ VSS VSS VDD VDD _03574_ sky130_fd_sc_hd__nand2_1
X_09213_ _03573_ VSS VSS VDD VDD _03575_ sky130_fd_sc_hd__inv_1
X_09214_ _03570_ _03575_ VSS VSS VDD VDD _03576_ sky130_fd_sc_hd__nand2_1
X_09215_ _03574_ _03576_ VSS VSS VDD VDD _03577_ sky130_fd_sc_hd__nand2_1
X_09216_ _03562_ _03566_ _03577_ VSS VSS VDD VDD _03578_ sky130_fd_sc_hd__nand3_1
X_09217_ _03565_ _03560_ VSS VSS VDD VDD _03579_ sky130_fd_sc_hd__nand2_1
X_09218_ _03557_ _03559_ VSS VSS VDD VDD _03580_ sky130_fd_sc_hd__nand2_1
X_09219_ _03571_ _03575_ VSS VSS VDD VDD _03581_ sky130_fd_sc_hd__nand2_1
X_09220_ _03570_ _03573_ VSS VSS VDD VDD _03582_ sky130_fd_sc_hd__nand2_1
X_09221_ _03581_ _03582_ VSS VSS VDD VDD _03584_ sky130_fd_sc_hd__nand2_1
X_09222_ _03579_ _03580_ _03584_ VSS VSS VDD VDD _03585_ sky130_fd_sc_hd__nand3_1
X_09223_ _03578_ _03585_ VSS VSS VDD VDD _03586_ sky130_fd_sc_hd__nand2_1
X_09224_ _03257_ _03276_ VSS VSS VDD VDD _03587_ sky130_fd_sc_hd__nor2_1
X_09225_ _03258_ _03273_ _03587_ VSS VSS VDD VDD _03588_ sky130_fd_sc_hd__a21oi_2
X_09226_ _03588_ VSS VSS VDD VDD _03589_ sky130_fd_sc_hd__inv_1
X_09227_ _03586_ _03589_ VSS VSS VDD VDD _03590_ sky130_fd_sc_hd__nand2_1
X_09228_ _03579_ _03580_ _03577_ VSS VSS VDD VDD _03591_ sky130_fd_sc_hd__nand3_1
X_09229_ _03562_ _03566_ _03584_ VSS VSS VDD VDD _03592_ sky130_fd_sc_hd__nand3_1
X_09230_ _03591_ _03592_ VSS VSS VDD VDD _03593_ sky130_fd_sc_hd__nand2_1
X_09231_ _03593_ _03588_ VSS VSS VDD VDD _03595_ sky130_fd_sc_hd__nand2_1
X_09232_ _03307_ wrapped_design.b1_skew\[7\] _03306_ VSS VSS
+ VDD VDD _03596_ sky130_fd_sc_hd__a21oi_1
X_09233_ _03596_ VSS VSS VDD VDD _03597_ sky130_fd_sc_hd__inv_1
X_09234_ _03312_ _03304_ VSS VSS VDD VDD _03598_ sky130_fd_sc_hd__nand2_1
X_09235_ _00713_ _03312_ _03598_ VSS VSS VDD VDD _03599_ sky130_fd_sc_hd__o21ai_0
X_09236_ _03265_ _03271_ _03261_ VSS VSS VDD VDD _03600_ sky130_fd_sc_hd__a21oi_1
X_09237_ _03599_ _03600_ VSS VSS VDD VDD _03601_ sky130_fd_sc_hd__nor2_1
X_09238_ _03600_ _03599_ VSS VSS VDD VDD _03602_ sky130_fd_sc_hd__nand2_1
X_09239_ _03602_ VSS VSS VDD VDD _03603_ sky130_fd_sc_hd__inv_1
X_09240_ _03601_ _03603_ VSS VSS VDD VDD _03604_ sky130_fd_sc_hd__nor2_1
X_09241_ _03597_ _03604_ VSS VSS VDD VDD _03606_ sky130_fd_sc_hd__nor2_1
X_09242_ _03604_ _03597_ VSS VSS VDD VDD _03607_ sky130_fd_sc_hd__nand2_1
X_09243_ _03607_ VSS VSS VDD VDD _03608_ sky130_fd_sc_hd__inv_1
X_09244_ _03606_ _03608_ VSS VSS VDD VDD _03609_ sky130_fd_sc_hd__nor2_2
X_09245_ _03590_ _03595_ _03609_ VSS VSS VDD VDD _03610_ sky130_fd_sc_hd__nand3_1
X_09246_ _03593_ _03589_ VSS VSS VDD VDD _03611_ sky130_fd_sc_hd__nand2_1
X_09247_ _03588_ _03591_ _03592_ VSS VSS VDD VDD _03612_ sky130_fd_sc_hd__nand3_1
X_09248_ _03606_ VSS VSS VDD VDD _03613_ sky130_fd_sc_hd__inv_1
X_09249_ _03613_ _03607_ VSS VSS VDD VDD _03614_ sky130_fd_sc_hd__nand2_1
X_09250_ _03611_ _03612_ _03614_ VSS VSS VDD VDD _03615_ sky130_fd_sc_hd__nand3_1
X_09251_ _03610_ _03615_ VSS VSS VDD VDD _03617_ sky130_fd_sc_hd__nand2_1
X_09252_ _03299_ _03283_ VSS VSS VDD VDD _03618_ sky130_fd_sc_hd__nor2_1
X_09253_ _03300_ _03334_ _03618_ VSS VSS VDD VDD _03619_ sky130_fd_sc_hd__a21oi_2
X_09254_ _03619_ VSS VSS VDD VDD _03620_ sky130_fd_sc_hd__inv_1
X_09255_ _03617_ _03620_ VSS VSS VDD VDD _03621_ sky130_fd_sc_hd__nand2_1
X_09256_ _03590_ _03595_ _03614_ VSS VSS VDD VDD _03622_ sky130_fd_sc_hd__nand3_1
X_09257_ _03611_ _03612_ _03609_ VSS VSS VDD VDD _03623_ sky130_fd_sc_hd__nand3_1
X_09258_ _03622_ _03623_ VSS VSS VDD VDD _03624_ sky130_fd_sc_hd__nand2_1
X_09259_ _03624_ _03619_ VSS VSS VDD VDD _03625_ sky130_fd_sc_hd__nand2_1
X_09260_ _03338_ _03332_ VSS VSS VDD VDD _03626_ sky130_fd_sc_hd__nand2_1
X_09261_ _03626_ VSS VSS VDD VDD _03628_ sky130_fd_sc_hd__inv_1
X_09262_ _03621_ _03625_ _03628_ VSS VSS VDD VDD _03629_ sky130_fd_sc_hd__nand3_1
X_09263_ _03624_ _03620_ VSS VSS VDD VDD _03630_ sky130_fd_sc_hd__nand2_1
X_09264_ _03619_ _03622_ _03623_ VSS VSS VDD VDD _03631_ sky130_fd_sc_hd__nand3_2
X_09265_ _03630_ _03631_ _03626_ VSS VSS VDD VDD _03632_ sky130_fd_sc_hd__nand3_1
X_09266_ _03629_ _03632_ VSS VSS VDD VDD _03633_ sky130_fd_sc_hd__nand2_1
X_09267_ _03391_ _03382_ _03389_ VSS VSS VDD VDD _03634_ sky130_fd_sc_hd__a21boi_1
X_09268_ _03633_ _03634_ VSS VSS VDD VDD _03635_ sky130_fd_sc_hd__nand2_1
X_09269_ _03621_ _03625_ _03626_ VSS VSS VDD VDD _03636_ sky130_fd_sc_hd__nand3_1
X_09270_ _03630_ _03631_ _03628_ VSS VSS VDD VDD _03637_ sky130_fd_sc_hd__nand3_1
X_09271_ _03636_ _03637_ VSS VSS VDD VDD _03639_ sky130_fd_sc_hd__nand2_1
X_09272_ _03392_ _03389_ VSS VSS VDD VDD _03640_ sky130_fd_sc_hd__nand2_1
X_09273_ _03639_ _03640_ VSS VSS VDD VDD _03641_ sky130_fd_sc_hd__nand2_1
X_09274_ _03635_ _03641_ VSS VSS VDD VDD _03642_ sky130_fd_sc_hd__nand2_1
X_09275_ _03577_ _03580_ _03579_ VSS VSS VDD VDD _03643_ sky130_fd_sc_hd__a21boi_1
X_09276_ wrapped_design.a00_right\[7\] wrapped_design.b1_skew\[2\]
+ VSS VSS VDD VDD _03644_ sky130_fd_sc_hd__nand2_4
X_09277_ wrapped_design.b1_skew\[4\] wrapped_design.a00_right\[6\]
+ VSS VSS VDD VDD _03645_ sky130_fd_sc_hd__nand2_1
X_09278_ wrapped_design.b1_skew\[3\] wrapped_design.a00_right\[6\]
+ VSS VSS VDD VDD _03646_ sky130_fd_sc_hd__nand2_1
X_09279_ _03646_ _03567_ VSS VSS VDD VDD _03647_ sky130_fd_sc_hd__nand2_1
X_09280_ _03645_ _03568_ _03647_ VSS VSS VDD VDD _03648_ sky130_fd_sc_hd__o21ai_2
X_09281_ _03644_ _03648_ VSS VSS VDD VDD _03650_ sky130_fd_sc_hd__xor2_1
X_09282_ wrapped_design.a00_right\[2\] _03235_ VSS VSS VDD
+ VDD _03651_ sky130_fd_sc_hd__nor2_2
X_09283_ wrapped_design.b1_skew\[6\] wrapped_design.a00_right\[3\]
+ VSS VSS VDD VDD _03652_ sky130_fd_sc_hd__nand2_1
X_09284_ _03651_ _03652_ VSS VSS VDD VDD _03653_ sky130_fd_sc_hd__nand2_1
X_09285_ _03652_ VSS VSS VDD VDD _03654_ sky130_fd_sc_hd__inv_1
X_09286_ wrapped_design.a00_right\[2\] VSS VSS VDD VDD _03655_
+ sky130_fd_sc_hd__inv_2
X_09287_ _03655_ wrapped_design.b1_skew\[7\] VSS VSS VDD VDD
+ _03656_ sky130_fd_sc_hd__nand2_1
X_09288_ _03654_ _03656_ VSS VSS VDD VDD _03657_ sky130_fd_sc_hd__nand2_1
X_09289_ wrapped_design.b1_skew\[5\] wrapped_design.a00_right\[4\]
+ VSS VSS VDD VDD _03658_ sky130_fd_sc_hd__nand2_1
X_09290_ _03658_ VSS VSS VDD VDD _03659_ sky130_fd_sc_hd__inv_1
X_09291_ _03653_ _03657_ _03659_ VSS VSS VDD VDD _03661_ sky130_fd_sc_hd__nand3_1
X_09292_ _03651_ _03654_ VSS VSS VDD VDD _03662_ sky130_fd_sc_hd__nand2_1
X_09293_ _03656_ _03652_ VSS VSS VDD VDD _03663_ sky130_fd_sc_hd__nand2_1
X_09294_ _03662_ _03663_ _03658_ VSS VSS VDD VDD _03664_ sky130_fd_sc_hd__nand3_1
X_09295_ _03661_ _03664_ VSS VSS VDD VDD _03665_ sky130_fd_sc_hd__nand2_1
X_09296_ _03556_ _03553_ VSS VSS VDD VDD _03666_ sky130_fd_sc_hd__nand2_1
X_09297_ _03665_ _03666_ VSS VSS VDD VDD _03667_ sky130_fd_sc_hd__nand2_1
X_09298_ _03653_ _03657_ _03658_ VSS VSS VDD VDD _03668_ sky130_fd_sc_hd__nand3_1
X_09299_ _03662_ _03663_ _03659_ VSS VSS VDD VDD _03669_ sky130_fd_sc_hd__nand3_1
X_09300_ _03668_ _03669_ VSS VSS VDD VDD _03670_ sky130_fd_sc_hd__nand2_1
X_09301_ _03544_ _03548_ VSS VSS VDD VDD _03672_ sky130_fd_sc_hd__nor2_1
X_09302_ _03554_ _03555_ _03672_ VSS VSS VDD VDD _03673_ sky130_fd_sc_hd__a21oi_1
X_09303_ _03670_ _03673_ VSS VSS VDD VDD _03674_ sky130_fd_sc_hd__nand2_1
X_09304_ _03650_ _03667_ _03674_ VSS VSS VDD VDD _03675_ sky130_fd_sc_hd__nand3_1
X_09305_ _03670_ _03666_ VSS VSS VDD VDD _03676_ sky130_fd_sc_hd__nand2_1
X_09306_ _03665_ _03673_ VSS VSS VDD VDD _03677_ sky130_fd_sc_hd__nand2_1
X_09307_ _03648_ VSS VSS VDD VDD _03678_ sky130_fd_sc_hd__inv_1
X_09308_ _03644_ VSS VSS VDD VDD _03679_ sky130_fd_sc_hd__inv_2
X_09309_ _03678_ _03679_ VSS VSS VDD VDD _03680_ sky130_fd_sc_hd__nand2_1
X_09310_ _03648_ _03644_ VSS VSS VDD VDD _03681_ sky130_fd_sc_hd__nand2_1
X_09311_ _03680_ _03681_ VSS VSS VDD VDD _03683_ sky130_fd_sc_hd__nand2_1
X_09312_ _03676_ _03677_ _03683_ VSS VSS VDD VDD _03684_ sky130_fd_sc_hd__nand3_1
X_09313_ _03675_ _03684_ VSS VSS VDD VDD _03685_ sky130_fd_sc_hd__nand2_1
X_09314_ _03643_ _03685_ VSS VSS VDD VDD _03686_ sky130_fd_sc_hd__nand2_1
X_09315_ _03650_ _03676_ _03677_ VSS VSS VDD VDD _03687_ sky130_fd_sc_hd__nand3_1
X_09316_ _03667_ _03674_ _03683_ VSS VSS VDD VDD _03688_ sky130_fd_sc_hd__nand3_1
X_09317_ _03687_ _03688_ VSS VSS VDD VDD _03689_ sky130_fd_sc_hd__nand2_1
X_09318_ _03591_ _03579_ VSS VSS VDD VDD _03690_ sky130_fd_sc_hd__nand2_1
X_09319_ _03689_ _03690_ VSS VSS VDD VDD _03691_ sky130_fd_sc_hd__nand2_1
X_09320_ _03598_ VSS VSS VDD VDD _03692_ sky130_fd_sc_hd__inv_1
X_09321_ _03567_ _03262_ VSS VSS VDD VDD _03694_ sky130_fd_sc_hd__nor2_1
X_09322_ _03569_ _03575_ _03694_ VSS VSS VDD VDD _03695_ sky130_fd_sc_hd__a21oi_1
X_09323_ _03692_ _03695_ VSS VSS VDD VDD _03696_ sky130_fd_sc_hd__nor2_1
X_09324_ _03696_ VSS VSS VDD VDD _03697_ sky130_fd_sc_hd__inv_1
X_09325_ _03695_ _03692_ VSS VSS VDD VDD _03698_ sky130_fd_sc_hd__nand2_1
X_09326_ _03697_ _03698_ VSS VSS VDD VDD _03699_ sky130_fd_sc_hd__nand2_1
X_09327_ _03699_ VSS VSS VDD VDD _03700_ sky130_fd_sc_hd__inv_1
X_09328_ _03686_ _03691_ _03700_ VSS VSS VDD VDD _03701_ sky130_fd_sc_hd__nand3_1
X_09329_ _03643_ _03689_ VSS VSS VDD VDD _03702_ sky130_fd_sc_hd__nand2_1
X_09330_ _03685_ _03690_ VSS VSS VDD VDD _03703_ sky130_fd_sc_hd__nand2_1
X_09331_ _03702_ _03703_ _03699_ VSS VSS VDD VDD _03705_ sky130_fd_sc_hd__nand3_1
X_09332_ _03701_ _03705_ VSS VSS VDD VDD _03706_ sky130_fd_sc_hd__nand2_1
X_09333_ _03609_ _03595_ _03590_ VSS VSS VDD VDD _03707_ sky130_fd_sc_hd__a21boi_2
X_09334_ _03706_ _03707_ VSS VSS VDD VDD _03708_ sky130_fd_sc_hd__nand2_2
X_09335_ _03702_ _03703_ _03700_ VSS VSS VDD VDD _03709_ sky130_fd_sc_hd__nand3_1
X_09336_ _03686_ _03691_ _03699_ VSS VSS VDD VDD _03710_ sky130_fd_sc_hd__nand3_1
X_09337_ _03709_ _03710_ VSS VSS VDD VDD _03711_ sky130_fd_sc_hd__nand2_1
X_09338_ _03610_ _03590_ VSS VSS VDD VDD _03712_ sky130_fd_sc_hd__nand2_1
X_09339_ _03711_ _03712_ VSS VSS VDD VDD _03713_ sky130_fd_sc_hd__nand2_2
X_09340_ _03601_ _03608_ VSS VSS VDD VDD _03714_ sky130_fd_sc_hd__nor2_1
X_09341_ _03714_ VSS VSS VDD VDD _03716_ sky130_fd_sc_hd__inv_1
X_09342_ _03708_ _03713_ _03716_ VSS VSS VDD VDD _03717_ sky130_fd_sc_hd__nand3_2
X_09343_ _03711_ _03707_ VSS VSS VDD VDD _03718_ sky130_fd_sc_hd__nand2_1
X_09344_ _03706_ _03712_ VSS VSS VDD VDD _03719_ sky130_fd_sc_hd__nand2_1
X_09345_ _03718_ _03719_ _03714_ VSS VSS VDD VDD _03720_ sky130_fd_sc_hd__nand3_1
X_09346_ _03717_ _03720_ VSS VSS VDD VDD _03721_ sky130_fd_sc_hd__nand2_1
X_09347_ _03619_ _03617_ VSS VSS VDD VDD _03722_ sky130_fd_sc_hd__nor2_1
X_09348_ _03631_ _03626_ _03722_ VSS VSS VDD VDD _03723_ sky130_fd_sc_hd__a21oi_2
X_09349_ _03723_ VSS VSS VDD VDD _03724_ sky130_fd_sc_hd__inv_1
X_09350_ _03721_ _03724_ VSS VSS VDD VDD _03725_ sky130_fd_sc_hd__nand2_1
X_09351_ _03723_ _03717_ _03720_ VSS VSS VDD VDD _03727_ sky130_fd_sc_hd__nand3_1
X_09352_ _03725_ _03727_ VSS VSS VDD VDD _03728_ sky130_fd_sc_hd__nand2_1
X_09353_ _03728_ VSS VSS VDD VDD _03729_ sky130_fd_sc_hd__inv_1
X_09354_ _03642_ _03729_ VSS VSS VDD VDD _03730_ sky130_fd_sc_hd__nor2_1
X_09355_ _03542_ _03730_ VSS VSS VDD VDD _03731_ sky130_fd_sc_hd__nand2_1
X_09356_ _03718_ _03719_ _03716_ VSS VSS VDD VDD _03732_ sky130_fd_sc_hd__nand3_1
X_09357_ _03708_ _03713_ _03714_ VSS VSS VDD VDD _03733_ sky130_fd_sc_hd__nand3_1
X_09358_ _03732_ _03733_ VSS VSS VDD VDD _03734_ sky130_fd_sc_hd__nand2_1
X_09359_ _03734_ _03724_ VSS VSS VDD VDD _03735_ sky130_fd_sc_hd__nand2_1
X_09360_ _03735_ _03641_ VSS VSS VDD VDD _03736_ sky130_fd_sc_hd__nand2_1
X_09361_ _03721_ _03723_ VSS VSS VDD VDD _03738_ sky130_fd_sc_hd__nand2_1
X_09362_ _03736_ _03738_ VSS VSS VDD VDD _03739_ sky130_fd_sc_hd__nand2_1
X_09363_ _03731_ _03739_ VSS VSS VDD VDD _03740_ sky130_fd_sc_hd__nand2_1
X_09364_ wrapped_design.a00_right\[6\] _03235_ VSS VSS VDD
+ VDD _03741_ sky130_fd_sc_hd__nor2_1
X_09365_ wrapped_design.a00_right\[7\] wrapped_design.b1_skew\[6\]
+ VSS VSS VDD VDD _03742_ sky130_fd_sc_hd__nand2_1
X_09366_ _03741_ _03742_ VSS VSS VDD VDD _03743_ sky130_fd_sc_hd__nand2_1
X_09367_ _03742_ VSS VSS VDD VDD _03744_ sky130_fd_sc_hd__inv_1
X_09368_ _03203_ wrapped_design.b1_skew\[7\] VSS VSS VDD VDD
+ _03745_ sky130_fd_sc_hd__nand2_1
X_09369_ _03744_ _03745_ VSS VSS VDD VDD _03746_ sky130_fd_sc_hd__nand2_1
X_09370_ wrapped_design.a00_right\[7\] wrapped_design.b1_skew\[5\]
+ VSS VSS VDD VDD _03747_ sky130_fd_sc_hd__nand2_2
X_09371_ _03743_ _03746_ _03747_ VSS VSS VDD VDD _03749_ sky130_fd_sc_hd__nand3_1
X_09372_ _03741_ _03744_ VSS VSS VDD VDD _03750_ sky130_fd_sc_hd__nand2_1
X_09373_ _03745_ _03742_ VSS VSS VDD VDD _03751_ sky130_fd_sc_hd__nand2_1
X_09374_ _03747_ VSS VSS VDD VDD _03752_ sky130_fd_sc_hd__inv_2
X_09375_ _03750_ _03751_ _03752_ VSS VSS VDD VDD _03753_ sky130_fd_sc_hd__nand3_1
X_09376_ _03749_ _03753_ VSS VSS VDD VDD _03754_ sky130_fd_sc_hd__nand2_1
X_09377_ wrapped_design.a00_right\[5\] VSS VSS VDD VDD _03755_
+ sky130_fd_sc_hd__inv_1
X_09378_ _03755_ wrapped_design.b1_skew\[7\] VSS VSS VDD VDD
+ _03756_ sky130_fd_sc_hd__nand2_1
X_09379_ wrapped_design.b1_skew\[6\] wrapped_design.a00_right\[6\]
+ VSS VSS VDD VDD _03757_ sky130_fd_sc_hd__nand2_1
X_09380_ _03756_ _03757_ VSS VSS VDD VDD _03758_ sky130_fd_sc_hd__nand2_1
X_09381_ _03757_ _03756_ VSS VSS VDD VDD _03760_ sky130_fd_sc_hd__nor2_1
X_09382_ _03758_ _03752_ _03760_ VSS VSS VDD VDD _03761_ sky130_fd_sc_hd__a21oi_2
X_09383_ _03761_ VSS VSS VDD VDD _03762_ sky130_fd_sc_hd__inv_1
X_09384_ _03754_ _03762_ VSS VSS VDD VDD _03763_ sky130_fd_sc_hd__nand2_1
X_09385_ _03743_ _03746_ _03752_ VSS VSS VDD VDD _03764_ sky130_fd_sc_hd__nand3_1
X_09386_ _03750_ _03751_ _03747_ VSS VSS VDD VDD _03765_ sky130_fd_sc_hd__nand3_1
X_09387_ _03764_ _03765_ VSS VSS VDD VDD _03766_ sky130_fd_sc_hd__nand2_1
X_09388_ _03766_ _03761_ VSS VSS VDD VDD _03767_ sky130_fd_sc_hd__nand2_1
X_09389_ wrapped_design.a00_right\[7\] wrapped_design.b1_skew\[3\]
+ VSS VSS VDD VDD _03768_ sky130_fd_sc_hd__nand2_1
X_09390_ wrapped_design.a00_right\[7\] wrapped_design.b1_skew\[4\]
+ VSS VSS VDD VDD _03769_ sky130_fd_sc_hd__nand2_1
X_09391_ _03768_ _03769_ VSS VSS VDD VDD _03771_ sky130_fd_sc_hd__nand2_1
X_09392_ wrapped_design.a00_right\[7\] wrapped_design.b1_skew\[3\]
+ wrapped_design.b1_skew\[4\] VSS VSS VDD VDD _03772_ sky130_fd_sc_hd__nand3_1
X_09393_ _03771_ _03772_ VSS VSS VDD VDD _03773_ sky130_fd_sc_hd__nand2_1
X_09394_ _03773_ _03644_ VSS VSS VDD VDD _03774_ sky130_fd_sc_hd__nand2_2
X_09395_ _03771_ _03772_ _03679_ VSS VSS VDD VDD _03775_ sky130_fd_sc_hd__nand3_2
X_09396_ _03774_ _03775_ VSS VSS VDD VDD _03776_ sky130_fd_sc_hd__nand2_4
X_09397_ _03776_ VSS VSS VDD VDD _03777_ sky130_fd_sc_hd__inv_2
Xinput2 a_left[10] VSS VSS VDD VDD net2 sky130_fd_sc_hd__clkdlybuf4s50_1
X_09399_ _03763_ _03767_ _03777_ VSS VSS VDD VDD _03779_ sky130_fd_sc_hd__nand3_1
X_09400_ _03766_ _03762_ VSS VSS VDD VDD _03780_ sky130_fd_sc_hd__nand2_1
X_09401_ _03754_ _03761_ VSS VSS VDD VDD _03782_ sky130_fd_sc_hd__nand2_1
X_09402_ _03780_ _03782_ _03776_ VSS VSS VDD VDD _03783_ sky130_fd_sc_hd__nand3_1
X_09403_ _03779_ _03783_ VSS VSS VDD VDD _03784_ sky130_fd_sc_hd__nand2_1
X_09404_ wrapped_design.a00_right\[5\] _03235_ VSS VSS VDD
+ VDD _03785_ sky130_fd_sc_hd__nor2_1
X_09405_ _03785_ _03757_ VSS VSS VDD VDD _03786_ sky130_fd_sc_hd__nand2_1
X_09406_ _03757_ VSS VSS VDD VDD _03787_ sky130_fd_sc_hd__inv_1
X_09407_ _03787_ _03756_ VSS VSS VDD VDD _03788_ sky130_fd_sc_hd__nand2_1
X_09408_ _03786_ _03788_ _03747_ VSS VSS VDD VDD _03789_ sky130_fd_sc_hd__nand3_1
X_09409_ _03785_ _03787_ VSS VSS VDD VDD _03790_ sky130_fd_sc_hd__nand2_1
X_09410_ _03790_ _03758_ _03752_ VSS VSS VDD VDD _03791_ sky130_fd_sc_hd__nand3_1
X_09411_ _03789_ _03791_ VSS VSS VDD VDD _03793_ sky130_fd_sc_hd__nand2_1
X_09412_ wrapped_design.a00_right\[4\] VSS VSS VDD VDD _03794_
+ sky130_fd_sc_hd__inv_1
X_09413_ _03794_ wrapped_design.b1_skew\[7\] VSS VSS VDD VDD
+ _03795_ sky130_fd_sc_hd__nand2_1
X_09414_ wrapped_design.b1_skew\[6\] wrapped_design.a00_right\[5\]
+ VSS VSS VDD VDD _03796_ sky130_fd_sc_hd__nand2_1
X_09415_ _03795_ _03796_ VSS VSS VDD VDD _03797_ sky130_fd_sc_hd__nand2_1
X_09416_ wrapped_design.b1_skew\[5\] wrapped_design.a00_right\[6\]
+ VSS VSS VDD VDD _03798_ sky130_fd_sc_hd__nand2_1
X_09417_ _03798_ VSS VSS VDD VDD _03799_ sky130_fd_sc_hd__inv_1
X_09418_ wrapped_design.a00_right\[4\] _03235_ VSS VSS VDD
+ VDD _03800_ sky130_fd_sc_hd__nor2_1
X_09419_ _03796_ VSS VSS VDD VDD _03801_ sky130_fd_sc_hd__inv_1
X_09420_ _03800_ _03801_ VSS VSS VDD VDD _03802_ sky130_fd_sc_hd__nand2_1
X_09421_ _03802_ VSS VSS VDD VDD _03804_ sky130_fd_sc_hd__inv_1
X_09422_ _03797_ _03799_ _03804_ VSS VSS VDD VDD _03805_ sky130_fd_sc_hd__a21oi_1
X_09423_ _03793_ _03805_ VSS VSS VDD VDD _03806_ sky130_fd_sc_hd__nand2_1
X_09424_ _03786_ _03788_ _03752_ VSS VSS VDD VDD _03807_ sky130_fd_sc_hd__nand3_1
X_09425_ _03790_ _03758_ _03747_ VSS VSS VDD VDD _03808_ sky130_fd_sc_hd__nand3_1
X_09426_ _03807_ _03808_ VSS VSS VDD VDD _03809_ sky130_fd_sc_hd__nand2_1
X_09427_ _03802_ _03797_ _03799_ VSS VSS VDD VDD _03810_ sky130_fd_sc_hd__nand3_1
X_09428_ _03810_ _03802_ VSS VSS VDD VDD _03811_ sky130_fd_sc_hd__nand2_1
X_09429_ _03809_ _03811_ VSS VSS VDD VDD _03812_ sky130_fd_sc_hd__nand2_1
X_09430_ _03806_ _03812_ _03777_ VSS VSS VDD VDD _03813_ sky130_fd_sc_hd__nand3_2
X_09431_ _03813_ _03812_ VSS VSS VDD VDD _03815_ sky130_fd_sc_hd__nand2_1
X_09432_ _03784_ _03815_ VSS VSS VDD VDD _03816_ sky130_fd_sc_hd__nand2_1
X_09433_ _03780_ _03782_ _03777_ VSS VSS VDD VDD _03817_ sky130_fd_sc_hd__nand3_1
X_09434_ _03763_ _03767_ _03776_ VSS VSS VDD VDD _03818_ sky130_fd_sc_hd__nand3_1
X_09435_ _03817_ _03818_ VSS VSS VDD VDD _03819_ sky130_fd_sc_hd__nand2_1
X_09436_ _03812_ VSS VSS VDD VDD _03820_ sky130_fd_sc_hd__inv_1
X_09437_ _03806_ _03777_ _03820_ VSS VSS VDD VDD _03821_ sky130_fd_sc_hd__a21oi_2
X_09438_ _03819_ _03821_ VSS VSS VDD VDD _03822_ sky130_fd_sc_hd__nand2_1
X_09439_ _03775_ _03772_ VSS VSS VDD VDD _03823_ sky130_fd_sc_hd__nand2_1
X_09440_ _03598_ _03823_ VSS VSS VDD VDD _03824_ sky130_fd_sc_hd__nor2_1
X_09441_ _03823_ _03598_ VSS VSS VDD VDD _03826_ sky130_fd_sc_hd__nand2_2
X_09442_ _03826_ VSS VSS VDD VDD _03827_ sky130_fd_sc_hd__inv_2
X_09443_ _03824_ _03827_ VSS VSS VDD VDD _03828_ sky130_fd_sc_hd__nor2_4
X_09444_ _03816_ _03822_ _03828_ VSS VSS VDD VDD _03829_ sky130_fd_sc_hd__nand3_1
X_09445_ _03819_ _03815_ VSS VSS VDD VDD _03830_ sky130_fd_sc_hd__nand2_1
X_09446_ _03784_ _03821_ VSS VSS VDD VDD _03831_ sky130_fd_sc_hd__nand2_1
X_09447_ _03828_ VSS VSS VDD VDD _03832_ sky130_fd_sc_hd__inv_2
X_09448_ _03830_ _03831_ _03832_ VSS VSS VDD VDD _03833_ sky130_fd_sc_hd__nand3_1
X_09449_ _03829_ _03833_ VSS VSS VDD VDD _03834_ sky130_fd_sc_hd__nand2_1
X_09450_ _03800_ _03796_ VSS VSS VDD VDD _03835_ sky130_fd_sc_hd__nand2_1
X_09451_ _03801_ _03795_ VSS VSS VDD VDD _03837_ sky130_fd_sc_hd__nand2_1
X_09452_ _03835_ _03837_ _03798_ VSS VSS VDD VDD _03838_ sky130_fd_sc_hd__nand3_1
X_09453_ _03838_ _03810_ VSS VSS VDD VDD _03839_ sky130_fd_sc_hd__nand2_1
X_09454_ wrapped_design.a00_right\[3\] VSS VSS VDD VDD _03840_
+ sky130_fd_sc_hd__inv_1
X_09455_ _03840_ wrapped_design.b1_skew\[7\] VSS VSS VDD VDD
+ _03841_ sky130_fd_sc_hd__nand2_1
X_09456_ wrapped_design.b1_skew\[6\] wrapped_design.a00_right\[4\]
+ VSS VSS VDD VDD _03842_ sky130_fd_sc_hd__nand2_1
X_09457_ _03841_ _03842_ VSS VSS VDD VDD _03843_ sky130_fd_sc_hd__nand2_1
X_09458_ wrapped_design.b1_skew\[5\] wrapped_design.a00_right\[5\]
+ VSS VSS VDD VDD _03844_ sky130_fd_sc_hd__nand2_1
X_09459_ _03844_ VSS VSS VDD VDD _03845_ sky130_fd_sc_hd__inv_1
X_09460_ _03842_ _03841_ VSS VSS VDD VDD _03846_ sky130_fd_sc_hd__nor2_1
X_09461_ _03843_ _03845_ _03846_ VSS VSS VDD VDD _03848_ sky130_fd_sc_hd__a21oi_2
X_09462_ _03839_ _03848_ VSS VSS VDD VDD _03849_ sky130_fd_sc_hd__nand2_1
X_09463_ _03835_ _03837_ _03799_ VSS VSS VDD VDD _03850_ sky130_fd_sc_hd__nand3_1
X_09464_ _03802_ _03797_ _03798_ VSS VSS VDD VDD _03851_ sky130_fd_sc_hd__nand3_1
X_09465_ _03850_ _03851_ VSS VSS VDD VDD _03852_ sky130_fd_sc_hd__nand2_1
X_09466_ _03848_ VSS VSS VDD VDD _03853_ sky130_fd_sc_hd__inv_1
X_09467_ _03852_ _03853_ VSS VSS VDD VDD _03854_ sky130_fd_sc_hd__nand2_1
X_09468_ _03777_ _03849_ _03854_ VSS VSS VDD VDD _03855_ sky130_fd_sc_hd__a21boi_2
X_09469_ _03809_ _03805_ VSS VSS VDD VDD _03856_ sky130_fd_sc_hd__nand2_1
X_09470_ _03793_ _03811_ VSS VSS VDD VDD _03857_ sky130_fd_sc_hd__nand2_1
X_09471_ _03856_ _03857_ _03776_ VSS VSS VDD VDD _03859_ sky130_fd_sc_hd__nand3_1
X_09472_ _03813_ _03859_ VSS VSS VDD VDD _03860_ sky130_fd_sc_hd__nand2_1
X_09473_ _03855_ _03860_ VSS VSS VDD VDD _03861_ sky130_fd_sc_hd__nand2_1
X_09474_ _03856_ _03857_ _03777_ VSS VSS VDD VDD _03862_ sky130_fd_sc_hd__nand3_1
X_09475_ _03806_ _03812_ _03776_ VSS VSS VDD VDD _03863_ sky130_fd_sc_hd__nand3_1
X_09476_ _03862_ _03863_ VSS VSS VDD VDD _03864_ sky130_fd_sc_hd__nand2_1
X_09477_ _03854_ _03849_ _03777_ VSS VSS VDD VDD _03865_ sky130_fd_sc_hd__nand3_2
X_09478_ _03865_ _03854_ VSS VSS VDD VDD _03866_ sky130_fd_sc_hd__nand2_1
X_09479_ _03864_ _03866_ VSS VSS VDD VDD _03867_ sky130_fd_sc_hd__nand2_1
X_09480_ _03861_ _03867_ _03828_ VSS VSS VDD VDD _03868_ sky130_fd_sc_hd__nand3_1
X_09481_ _03868_ _03867_ VSS VSS VDD VDD _03870_ sky130_fd_sc_hd__nand2_1
X_09482_ _03834_ _03870_ VSS VSS VDD VDD _03871_ sky130_fd_sc_hd__nand2_1
X_09483_ _03830_ _03831_ _03828_ VSS VSS VDD VDD _03872_ sky130_fd_sc_hd__nand3_1
X_09484_ _03816_ _03822_ _03832_ VSS VSS VDD VDD _03873_ sky130_fd_sc_hd__nand3_1
X_09485_ _03872_ _03873_ VSS VSS VDD VDD _03874_ sky130_fd_sc_hd__nand2_1
X_09486_ _03867_ VSS VSS VDD VDD _03875_ sky130_fd_sc_hd__inv_1
X_09487_ _03861_ _03828_ _03875_ VSS VSS VDD VDD _03876_ sky130_fd_sc_hd__a21oi_1
X_09488_ _03874_ _03876_ VSS VSS VDD VDD _03877_ sky130_fd_sc_hd__nand2_1
X_09489_ _03871_ _03877_ _03827_ VSS VSS VDD VDD _03878_ sky130_fd_sc_hd__nand3_1
X_09490_ _03874_ _03870_ VSS VSS VDD VDD _03879_ sky130_fd_sc_hd__nand2_1
X_09491_ _03834_ _03876_ VSS VSS VDD VDD _03881_ sky130_fd_sc_hd__nand2_1
X_09492_ _03879_ _03881_ _03826_ VSS VSS VDD VDD _03882_ sky130_fd_sc_hd__nand3_1
X_09493_ _03878_ _03882_ VSS VSS VDD VDD _03883_ sky130_fd_sc_hd__nand2_1
X_09494_ _03768_ _03645_ VSS VSS VDD VDD _03884_ sky130_fd_sc_hd__nand2_1
X_09495_ _03768_ _03645_ VSS VSS VDD VDD _03885_ sky130_fd_sc_hd__nor2_1
X_09496_ _03884_ _03679_ _03885_ VSS VSS VDD VDD _03886_ sky130_fd_sc_hd__a21oi_1
X_09497_ _03692_ _03886_ VSS VSS VDD VDD _03887_ sky130_fd_sc_hd__nor2_2
X_09498_ _03887_ VSS VSS VDD VDD _03888_ sky130_fd_sc_hd__inv_1
X_09499_ _03886_ _03692_ VSS VSS VDD VDD _03889_ sky130_fd_sc_hd__nand2_1
X_09500_ _03888_ _03889_ VSS VSS VDD VDD _03890_ sky130_fd_sc_hd__nand2_1
X_09501_ _03890_ VSS VSS VDD VDD _03892_ sky130_fd_sc_hd__inv_1
X_09502_ _03839_ _03853_ VSS VSS VDD VDD _03893_ sky130_fd_sc_hd__nand2_1
X_09503_ _03852_ _03848_ VSS VSS VDD VDD _03894_ sky130_fd_sc_hd__nand2_1
X_09504_ _03893_ _03894_ _03776_ VSS VSS VDD VDD _03895_ sky130_fd_sc_hd__nand3_1
X_09505_ _03865_ _03895_ VSS VSS VDD VDD _03896_ sky130_fd_sc_hd__nand2_1
X_09506_ _03769_ _03646_ _03884_ VSS VSS VDD VDD _03897_ sky130_fd_sc_hd__o21ai_1
X_09507_ _03897_ VSS VSS VDD VDD _03898_ sky130_fd_sc_hd__inv_1
X_09508_ _03898_ _03679_ VSS VSS VDD VDD _03899_ sky130_fd_sc_hd__nand2_1
X_09509_ _03897_ _03644_ VSS VSS VDD VDD _03900_ sky130_fd_sc_hd__nand2_1
X_09510_ _03899_ _03900_ VSS VSS VDD VDD _03901_ sky130_fd_sc_hd__nand2_1
X_09511_ _03901_ VSS VSS VDD VDD _03903_ sky130_fd_sc_hd__inv_2
X_09512_ wrapped_design.a00_right\[3\] _03235_ VSS VSS VDD
+ VDD _03904_ sky130_fd_sc_hd__nor2_1
X_09513_ _03904_ _03842_ VSS VSS VDD VDD _03905_ sky130_fd_sc_hd__nand2_1
X_09514_ _03842_ VSS VSS VDD VDD _03906_ sky130_fd_sc_hd__inv_1
X_09515_ _03906_ _03841_ VSS VSS VDD VDD _03907_ sky130_fd_sc_hd__nand2_1
X_09516_ _03905_ _03907_ _03844_ VSS VSS VDD VDD _03908_ sky130_fd_sc_hd__nand3_1
X_09517_ _03904_ _03906_ VSS VSS VDD VDD _03909_ sky130_fd_sc_hd__nand2_1
X_09518_ _03909_ _03843_ _03845_ VSS VSS VDD VDD _03910_ sky130_fd_sc_hd__nand3_1
X_09519_ _03908_ _03910_ VSS VSS VDD VDD _03911_ sky130_fd_sc_hd__nand2_1
X_09520_ _03662_ VSS VSS VDD VDD _03912_ sky130_fd_sc_hd__inv_1
X_09521_ _03663_ _03659_ _03912_ VSS VSS VDD VDD _03914_ sky130_fd_sc_hd__a21oi_1
X_09522_ _03911_ _03914_ VSS VSS VDD VDD _03915_ sky130_fd_sc_hd__nand2_1
X_09523_ _03905_ _03907_ _03845_ VSS VSS VDD VDD _03916_ sky130_fd_sc_hd__nand3_1
X_09524_ _03909_ _03843_ _03844_ VSS VSS VDD VDD _03917_ sky130_fd_sc_hd__nand3_1
X_09525_ _03916_ _03917_ VSS VSS VDD VDD _03918_ sky130_fd_sc_hd__nand2_1
X_09526_ _03669_ _03662_ VSS VSS VDD VDD _03919_ sky130_fd_sc_hd__nand2_1
X_09527_ _03918_ _03919_ VSS VSS VDD VDD _03920_ sky130_fd_sc_hd__nand2_1
X_09528_ _03920_ VSS VSS VDD VDD _03921_ sky130_fd_sc_hd__inv_1
X_09529_ _03903_ _03915_ _03921_ VSS VSS VDD VDD _03922_ sky130_fd_sc_hd__a21oi_2
X_09530_ _03896_ _03922_ VSS VSS VDD VDD _03923_ sky130_fd_sc_hd__nand2_2
X_09531_ _03903_ _03920_ _03915_ VSS VSS VDD VDD _03925_ sky130_fd_sc_hd__nand3_1
X_09532_ _03925_ _03920_ VSS VSS VDD VDD _03926_ sky130_fd_sc_hd__nand2_1
X_09533_ _03893_ _03894_ _03777_ VSS VSS VDD VDD _03927_ sky130_fd_sc_hd__nand3_1
X_09534_ _03854_ _03849_ _03776_ VSS VSS VDD VDD _03928_ sky130_fd_sc_hd__nand3_1
X_09535_ _03927_ _03928_ VSS VSS VDD VDD _03929_ sky130_fd_sc_hd__nand2_1
X_09536_ _03926_ _03929_ VSS VSS VDD VDD _03930_ sky130_fd_sc_hd__nand2_1
X_09537_ _03892_ _03923_ _03930_ VSS VSS VDD VDD _03931_ sky130_fd_sc_hd__a21boi_2
X_09538_ _03855_ _03864_ VSS VSS VDD VDD _03932_ sky130_fd_sc_hd__nand2_1
X_09539_ _03860_ _03866_ VSS VSS VDD VDD _03933_ sky130_fd_sc_hd__nand2_1
X_09540_ _03932_ _03933_ _03832_ VSS VSS VDD VDD _03934_ sky130_fd_sc_hd__nand3_1
X_09541_ _03868_ _03934_ VSS VSS VDD VDD _03936_ sky130_fd_sc_hd__nand2_1
X_09542_ _03931_ _03936_ VSS VSS VDD VDD _03937_ sky130_fd_sc_hd__nand2_1
X_09543_ _03932_ _03933_ _03828_ VSS VSS VDD VDD _03938_ sky130_fd_sc_hd__nand3_1
X_09544_ _03861_ _03867_ _03832_ VSS VSS VDD VDD _03939_ sky130_fd_sc_hd__nand3_1
X_09545_ _03938_ _03939_ VSS VSS VDD VDD _03940_ sky130_fd_sc_hd__nand2_1
X_09546_ _03930_ _03923_ _03892_ VSS VSS VDD VDD _03941_ sky130_fd_sc_hd__nand3_1
X_09547_ _03941_ _03930_ VSS VSS VDD VDD _03942_ sky130_fd_sc_hd__nand2_1
X_09548_ _03940_ _03942_ VSS VSS VDD VDD _03943_ sky130_fd_sc_hd__nand2_2
X_09549_ _03887_ _03937_ _03943_ VSS VSS VDD VDD _03944_ sky130_fd_sc_hd__a21boi_1
X_09550_ _03883_ _03944_ VSS VSS VDD VDD _03945_ sky130_fd_sc_hd__nand2_1
X_09551_ _03879_ _03881_ _03827_ VSS VSS VDD VDD _03947_ sky130_fd_sc_hd__nand3_1
X_09552_ _03871_ _03877_ _03826_ VSS VSS VDD VDD _03948_ sky130_fd_sc_hd__nand3_1
X_09553_ _03947_ _03948_ VSS VSS VDD VDD _03949_ sky130_fd_sc_hd__nand2_1
X_09554_ _03937_ _03943_ _03887_ VSS VSS VDD VDD _03950_ sky130_fd_sc_hd__nand3_1
X_09555_ _03950_ _03943_ VSS VSS VDD VDD _03951_ sky130_fd_sc_hd__nand2_1
X_09556_ _03949_ _03951_ VSS VSS VDD VDD _03952_ sky130_fd_sc_hd__nand2_1
X_09557_ _03945_ _03952_ VSS VSS VDD VDD _03953_ sky130_fd_sc_hd__nand2_1
X_09558_ _03931_ _03940_ VSS VSS VDD VDD _03954_ sky130_fd_sc_hd__nand2_1
X_09559_ _03936_ _03942_ VSS VSS VDD VDD _03955_ sky130_fd_sc_hd__nand2_1
X_09560_ _03954_ _03955_ _03887_ VSS VSS VDD VDD _03956_ sky130_fd_sc_hd__nand3_1
X_09561_ _03937_ _03943_ _03888_ VSS VSS VDD VDD _03958_ sky130_fd_sc_hd__nand3_1
X_09562_ _03956_ _03958_ VSS VSS VDD VDD _03959_ sky130_fd_sc_hd__nand2_1
X_09563_ _03645_ _03568_ VSS VSS VDD VDD _03960_ sky130_fd_sc_hd__nor2_1
X_09564_ _03647_ _03679_ _03960_ VSS VSS VDD VDD _03961_ sky130_fd_sc_hd__a21oi_1
X_09565_ _03692_ _03961_ VSS VSS VDD VDD _03962_ sky130_fd_sc_hd__nor2_1
X_09566_ _03926_ _03896_ VSS VSS VDD VDD _03963_ sky130_fd_sc_hd__nand2_1
X_09567_ _03929_ _03922_ VSS VSS VDD VDD _03964_ sky130_fd_sc_hd__nand2_1
X_09568_ _03963_ _03964_ _03890_ VSS VSS VDD VDD _03965_ sky130_fd_sc_hd__nand3_1
X_09569_ _03941_ _03965_ VSS VSS VDD VDD _03966_ sky130_fd_sc_hd__nand2_1
X_09570_ _03918_ _03914_ VSS VSS VDD VDD _03967_ sky130_fd_sc_hd__nand2_1
X_09571_ _03911_ _03919_ VSS VSS VDD VDD _03969_ sky130_fd_sc_hd__nand2_1
X_09572_ _03967_ _03969_ _03901_ VSS VSS VDD VDD _03970_ sky130_fd_sc_hd__nand3_1
X_09573_ _03925_ _03970_ VSS VSS VDD VDD _03971_ sky130_fd_sc_hd__nand2_1
X_09574_ _03650_ _03674_ _03667_ VSS VSS VDD VDD _03972_ sky130_fd_sc_hd__a21boi_1
X_09575_ _03971_ _03972_ VSS VSS VDD VDD _03973_ sky130_fd_sc_hd__nand2_1
X_09576_ _03962_ VSS VSS VDD VDD _03974_ sky130_fd_sc_hd__inv_1
X_09577_ _03961_ _03692_ VSS VSS VDD VDD _03975_ sky130_fd_sc_hd__nand2_1
X_09578_ _03974_ _03975_ VSS VSS VDD VDD _03976_ sky130_fd_sc_hd__nand2_1
X_09579_ _03976_ VSS VSS VDD VDD _03977_ sky130_fd_sc_hd__inv_1
X_09580_ _03903_ _03969_ _03967_ VSS VSS VDD VDD _03978_ sky130_fd_sc_hd__nand3_1
X_09581_ _03915_ _03920_ _03901_ VSS VSS VDD VDD _03980_ sky130_fd_sc_hd__nand3_1
X_09582_ _03978_ _03980_ VSS VSS VDD VDD _03981_ sky130_fd_sc_hd__nand2_1
X_09583_ _03675_ _03667_ VSS VSS VDD VDD _03982_ sky130_fd_sc_hd__nand2_1
X_09584_ _03981_ _03982_ VSS VSS VDD VDD _03983_ sky130_fd_sc_hd__nand2_1
X_09585_ _03983_ VSS VSS VDD VDD _03984_ sky130_fd_sc_hd__inv_1
X_09586_ _03973_ _03977_ _03984_ VSS VSS VDD VDD _03985_ sky130_fd_sc_hd__a21oi_1
X_09587_ _03966_ _03985_ VSS VSS VDD VDD _03986_ sky130_fd_sc_hd__nand2_1
X_09588_ _03963_ _03964_ _03892_ VSS VSS VDD VDD _03987_ sky130_fd_sc_hd__nand3_1
X_09589_ _03930_ _03923_ _03890_ VSS VSS VDD VDD _03988_ sky130_fd_sc_hd__nand3_1
X_09590_ _03987_ _03988_ VSS VSS VDD VDD _03989_ sky130_fd_sc_hd__nand2_1
X_09591_ _03983_ _03973_ _03977_ VSS VSS VDD VDD _03991_ sky130_fd_sc_hd__nand3_1
X_09592_ _03991_ _03983_ VSS VSS VDD VDD _03992_ sky130_fd_sc_hd__nand2_1
X_09593_ _03989_ _03992_ VSS VSS VDD VDD _03993_ sky130_fd_sc_hd__nand2_1
X_09594_ _03962_ _03986_ _03993_ VSS VSS VDD VDD _03994_ sky130_fd_sc_hd__a21boi_0
X_09595_ _03959_ _03994_ VSS VSS VDD VDD _03995_ sky130_fd_sc_hd__nand2_1
X_09596_ _03954_ _03955_ _03888_ VSS VSS VDD VDD _03996_ sky130_fd_sc_hd__nand3_1
X_09597_ _03950_ _03996_ VSS VSS VDD VDD _03997_ sky130_fd_sc_hd__nand2_1
X_09598_ _03993_ _03986_ _03962_ VSS VSS VDD VDD _03998_ sky130_fd_sc_hd__nand3_1
X_09599_ _03998_ _03993_ VSS VSS VDD VDD _03999_ sky130_fd_sc_hd__nand2_1
X_09600_ _03997_ _03999_ VSS VSS VDD VDD _04000_ sky130_fd_sc_hd__nand2_1
X_09601_ _03995_ _04000_ VSS VSS VDD VDD _04002_ sky130_fd_sc_hd__nand2_1
X_09602_ _03953_ _04002_ VSS VSS VDD VDD _04003_ sky130_fd_sc_hd__nand2_1
X_09603_ _03966_ _03992_ VSS VSS VDD VDD _04004_ sky130_fd_sc_hd__nand2_1
X_09604_ _03989_ _03985_ VSS VSS VDD VDD _04005_ sky130_fd_sc_hd__nand2_1
X_09605_ _04004_ _04005_ _03962_ VSS VSS VDD VDD _04006_ sky130_fd_sc_hd__nand3_1
X_09606_ _03993_ _03986_ _03974_ VSS VSS VDD VDD _04007_ sky130_fd_sc_hd__nand3_1
X_09607_ _04006_ _04007_ VSS VSS VDD VDD _04008_ sky130_fd_sc_hd__nand2_1
X_09608_ _03971_ _03982_ VSS VSS VDD VDD _04009_ sky130_fd_sc_hd__nand2_1
X_09609_ _03981_ _03972_ VSS VSS VDD VDD _04010_ sky130_fd_sc_hd__nand2_1
X_09610_ _04009_ _04010_ _03976_ VSS VSS VDD VDD _04011_ sky130_fd_sc_hd__nand3_1
X_09611_ _03991_ _04011_ VSS VSS VDD VDD _04013_ sky130_fd_sc_hd__nand2_1
X_09612_ _03700_ _03686_ _03691_ VSS VSS VDD VDD _04014_ sky130_fd_sc_hd__a21boi_2
X_09613_ _04013_ _04014_ VSS VSS VDD VDD _04015_ sky130_fd_sc_hd__nand2_1
X_09614_ _04009_ _04010_ _03977_ VSS VSS VDD VDD _04016_ sky130_fd_sc_hd__nand3_1
X_09615_ _03983_ _03973_ _03976_ VSS VSS VDD VDD _04017_ sky130_fd_sc_hd__nand3_1
X_09616_ _04016_ _04017_ VSS VSS VDD VDD _04018_ sky130_fd_sc_hd__nand2_1
X_09617_ _03701_ _03691_ VSS VSS VDD VDD _04019_ sky130_fd_sc_hd__nand2_1
X_09618_ _04018_ _04019_ VSS VSS VDD VDD _04020_ sky130_fd_sc_hd__nand2_1
X_09619_ _03696_ _04015_ _04020_ VSS VSS VDD VDD _04021_ sky130_fd_sc_hd__a21boi_1
X_09620_ _04008_ _04021_ VSS VSS VDD VDD _04022_ sky130_fd_sc_hd__nand2_1
X_09621_ _04004_ _04005_ _03974_ VSS VSS VDD VDD _04024_ sky130_fd_sc_hd__nand3_1
X_09622_ _03998_ _04024_ VSS VSS VDD VDD _04025_ sky130_fd_sc_hd__nand2_1
X_09623_ _04020_ _04015_ _03696_ VSS VSS VDD VDD _04026_ sky130_fd_sc_hd__nand3_1
X_09624_ _04026_ _04020_ VSS VSS VDD VDD _04027_ sky130_fd_sc_hd__nand2_1
X_09625_ _04025_ _04027_ VSS VSS VDD VDD _04028_ sky130_fd_sc_hd__nand2_1
X_09626_ _04022_ _04028_ VSS VSS VDD VDD _04029_ sky130_fd_sc_hd__nand2_1
X_09627_ _04013_ _04019_ VSS VSS VDD VDD _04030_ sky130_fd_sc_hd__nand2_1
X_09628_ _04018_ _04014_ VSS VSS VDD VDD _04031_ sky130_fd_sc_hd__nand2_1
X_09629_ _04030_ _04031_ _03696_ VSS VSS VDD VDD _04032_ sky130_fd_sc_hd__nand3_1
X_09630_ _04020_ _04015_ _03697_ VSS VSS VDD VDD _04033_ sky130_fd_sc_hd__nand3_1
X_09631_ _04032_ _04033_ VSS VSS VDD VDD _04035_ sky130_fd_sc_hd__nand2_1
X_09632_ _03716_ _03708_ _03713_ VSS VSS VDD VDD _04036_ sky130_fd_sc_hd__a21boi_2
X_09633_ _04035_ _04036_ VSS VSS VDD VDD _04037_ sky130_fd_sc_hd__nand2_1
X_09634_ _04030_ _04031_ _03697_ VSS VSS VDD VDD _04038_ sky130_fd_sc_hd__nand3_1
X_09635_ _04026_ _04038_ VSS VSS VDD VDD _04039_ sky130_fd_sc_hd__nand2_1
X_09636_ _03717_ _03713_ VSS VSS VDD VDD _04040_ sky130_fd_sc_hd__nand2_1
X_09637_ _04039_ _04040_ VSS VSS VDD VDD _04041_ sky130_fd_sc_hd__nand2_1
X_09638_ _04037_ _04041_ VSS VSS VDD VDD _04042_ sky130_fd_sc_hd__nand2_2
X_09639_ _04029_ _04042_ VSS VSS VDD VDD _04043_ sky130_fd_sc_hd__nand2_1
X_09640_ _04003_ _04043_ VSS VSS VDD VDD _04044_ sky130_fd_sc_hd__nor2_1
X_09641_ _03740_ _04044_ VSS VSS VDD VDD _04046_ sky130_fd_sc_hd__nand2_1
X_09642_ _03959_ _03999_ VSS VSS VDD VDD _04047_ sky130_fd_sc_hd__nand2_1
X_09643_ _03949_ _03944_ VSS VSS VDD VDD _04048_ sky130_fd_sc_hd__nand2_1
X_09644_ _03883_ _03951_ VSS VSS VDD VDD _04049_ sky130_fd_sc_hd__nand2_1
X_09645_ _04048_ _04049_ VSS VSS VDD VDD _04050_ sky130_fd_sc_hd__nand2_2
X_09646_ _04047_ _04050_ _04049_ VSS VSS VDD VDD _04051_ sky130_fd_sc_hd__o21ai_0
X_09647_ _04008_ _04027_ VSS VSS VDD VDD _04052_ sky130_fd_sc_hd__nand2_1
X_09648_ _04035_ _04040_ VSS VSS VDD VDD _04053_ sky130_fd_sc_hd__nand2_1
X_09649_ _04052_ _04053_ VSS VSS VDD VDD _04054_ sky130_fd_sc_hd__nand2_1
X_09650_ _04025_ _04021_ VSS VSS VDD VDD _04055_ sky130_fd_sc_hd__nand2_1
X_09651_ _04054_ _04055_ VSS VSS VDD VDD _04057_ sky130_fd_sc_hd__nand2_1
X_09652_ _04057_ _04003_ VSS VSS VDD VDD _04058_ sky130_fd_sc_hd__nor2_1
X_09653_ _04051_ _04058_ VSS VSS VDD VDD _04059_ sky130_fd_sc_hd__nor2_1
X_09654_ _04046_ _04059_ VSS VSS VDD VDD _04060_ sky130_fd_sc_hd__nand2_1
X_09655_ _03829_ _03816_ VSS VSS VDD VDD _04061_ sky130_fd_sc_hd__nand2_1
X_09656_ _03817_ _03780_ VSS VSS VDD VDD _04062_ sky130_fd_sc_hd__nand2_1
X_09657_ wrapped_design.a00_right\[7\] _03235_ VSS VSS VDD
+ VDD _04063_ sky130_fd_sc_hd__nor2_1
X_09658_ _03747_ _03742_ VSS VSS VDD VDD _04064_ sky130_fd_sc_hd__nand2_1
X_09659_ _03752_ wrapped_design.b1_skew\[6\] VSS VSS VDD VDD
+ _04065_ sky130_fd_sc_hd__nand2_1
X_09660_ _04063_ _04064_ _04065_ VSS VSS VDD VDD _04066_ sky130_fd_sc_hd__o21a_1
X_09661_ _03742_ _03745_ VSS VSS VDD VDD _04068_ sky130_fd_sc_hd__nor2_1
X_09662_ _03751_ _03752_ _04068_ VSS VSS VDD VDD _04069_ sky130_fd_sc_hd__a21oi_1
X_09663_ _04066_ _04069_ VSS VSS VDD VDD _04070_ sky130_fd_sc_hd__nand2_1
X_09664_ _04070_ _04065_ VSS VSS VDD VDD _04071_ sky130_fd_sc_hd__nand2_1
X_09665_ _04071_ _03776_ VSS VSS VDD VDD _04072_ sky130_fd_sc_hd__nand2_1
X_09666_ _04070_ _03777_ _04065_ VSS VSS VDD VDD _04073_ sky130_fd_sc_hd__nand3_1
X_09667_ _04072_ _04073_ VSS VSS VDD VDD _04074_ sky130_fd_sc_hd__nand2_1
X_09668_ _04062_ _04074_ VSS VSS VDD VDD _04075_ sky130_fd_sc_hd__nand2_1
X_09669_ _04071_ _03777_ VSS VSS VDD VDD _04076_ sky130_fd_sc_hd__nand2_1
X_09670_ _04070_ _03776_ _04065_ VSS VSS VDD VDD _04077_ sky130_fd_sc_hd__nand3_1
X_09671_ _04076_ _04077_ VSS VSS VDD VDD _04079_ sky130_fd_sc_hd__nand2_1
X_09672_ _03761_ _03754_ VSS VSS VDD VDD _04080_ sky130_fd_sc_hd__nor2_1
X_09673_ _03782_ _03777_ _04080_ VSS VSS VDD VDD _04081_ sky130_fd_sc_hd__a21oi_1
X_09674_ _04079_ _04081_ VSS VSS VDD VDD _04082_ sky130_fd_sc_hd__nand2_1
X_09675_ _04075_ _04082_ VSS VSS VDD VDD _04083_ sky130_fd_sc_hd__nand2_1
X_09676_ _04083_ _03828_ VSS VSS VDD VDD _04084_ sky130_fd_sc_hd__nand2_1
X_09677_ _04075_ _03832_ _04082_ VSS VSS VDD VDD _04085_ sky130_fd_sc_hd__nand3_1
X_09678_ _04084_ _04085_ VSS VSS VDD VDD _04086_ sky130_fd_sc_hd__nand2_1
X_09679_ _04061_ _04086_ VSS VSS VDD VDD _04087_ sky130_fd_sc_hd__nand2_1
X_09680_ _04083_ _03832_ VSS VSS VDD VDD _04088_ sky130_fd_sc_hd__nand2_1
X_09681_ _04075_ _03828_ _04082_ VSS VSS VDD VDD _04090_ sky130_fd_sc_hd__nand3_1
X_09682_ _04088_ _04090_ VSS VSS VDD VDD _04091_ sky130_fd_sc_hd__nand2_1
X_09683_ _03816_ VSS VSS VDD VDD _04092_ sky130_fd_sc_hd__inv_1
X_09684_ _03822_ _03828_ _04092_ VSS VSS VDD VDD _04093_ sky130_fd_sc_hd__a21oi_1
X_09685_ _04091_ _04093_ VSS VSS VDD VDD _04094_ sky130_fd_sc_hd__nand2_1
X_09686_ _04087_ _04094_ VSS VSS VDD VDD _04095_ sky130_fd_sc_hd__nand2_1
X_09687_ _04095_ _03827_ VSS VSS VDD VDD _04096_ sky130_fd_sc_hd__nand2_1
X_09688_ _04087_ _04094_ _03826_ VSS VSS VDD VDD _04097_ sky130_fd_sc_hd__nand3_1
X_09689_ _04096_ _04097_ VSS VSS VDD VDD _04098_ sky130_fd_sc_hd__nand2_1
X_09690_ _03947_ _03879_ VSS VSS VDD VDD _04099_ sky130_fd_sc_hd__nand2_1
X_09691_ _04098_ _04099_ VSS VSS VDD VDD _04101_ sky130_fd_sc_hd__nand2_1
X_09692_ _04095_ _03826_ VSS VSS VDD VDD _04102_ sky130_fd_sc_hd__nand2_1
X_09693_ _04087_ _04094_ _03827_ VSS VSS VDD VDD _04103_ sky130_fd_sc_hd__nand3_1
X_09694_ _04102_ _04103_ VSS VSS VDD VDD _04104_ sky130_fd_sc_hd__nand2_1
X_09695_ _03879_ VSS VSS VDD VDD _04105_ sky130_fd_sc_hd__inv_1
X_09696_ _03881_ _03827_ _04105_ VSS VSS VDD VDD _04106_ sky130_fd_sc_hd__a21oi_2
X_09697_ _04104_ _04106_ VSS VSS VDD VDD _04107_ sky130_fd_sc_hd__nand2_1
X_09698_ _04101_ _04107_ VSS VSS VDD VDD _04108_ sky130_fd_sc_hd__nand2_2
X_09699_ _04060_ _04108_ VSS VSS VDD VDD _04109_ sky130_fd_sc_hd__nand2_1
X_09700_ _04104_ _04099_ VSS VSS VDD VDD _04110_ sky130_fd_sc_hd__nand2_1
X_09701_ _04098_ _04106_ VSS VSS VDD VDD _04112_ sky130_fd_sc_hd__nand2_1
X_09702_ _04110_ _04112_ VSS VSS VDD VDD _04113_ sky130_fd_sc_hd__nand2_1
X_09703_ _04046_ _04113_ _04059_ VSS VSS VDD VDD _04114_ sky130_fd_sc_hd__nand3_1
X_09704_ _04109_ _04114_ VSS VSS VDD VDD _04115_ sky130_fd_sc_hd__nand2_1
X_09705_ _04115_ net66 VSS VSS VDD VDD _04116_ sky130_fd_sc_hd__nand2_1
X_09706_ _03723_ _03721_ VSS VSS VDD VDD _04117_ sky130_fd_sc_hd__nor2_1
X_09707_ _04042_ _04117_ VSS VSS VDD VDD _04118_ sky130_fd_sc_hd__nand2_1
X_09708_ _04118_ _04053_ VSS VSS VDD VDD _04119_ sky130_fd_sc_hd__nand2_1
X_09709_ _03641_ _03538_ VSS VSS VDD VDD _04120_ sky130_fd_sc_hd__nand2_1
X_09710_ _04120_ _03635_ VSS VSS VDD VDD _04121_ sky130_fd_sc_hd__nand2_1
X_09711_ _04042_ _03728_ VSS VSS VDD VDD _04123_ sky130_fd_sc_hd__nand2_2
X_09712_ _04121_ _04123_ VSS VSS VDD VDD _04124_ sky130_fd_sc_hd__nor2_1
X_09713_ _04119_ _04124_ VSS VSS VDD VDD _04125_ sky130_fd_sc_hd__nor2_2
X_09714_ _03633_ _03640_ VSS VSS VDD VDD _04126_ sky130_fd_sc_hd__nand2_1
X_09715_ _03639_ _03634_ VSS VSS VDD VDD _04127_ sky130_fd_sc_hd__nand2_1
X_09716_ _04126_ _04127_ VSS VSS VDD VDD _04128_ sky130_fd_sc_hd__nand2_1
X_09717_ _04128_ _03443_ VSS VSS VDD VDD _04129_ sky130_fd_sc_hd__nand2_1
X_09718_ _04129_ _04123_ VSS VSS VDD VDD _04130_ sky130_fd_sc_hd__nor2_2
X_09719_ _03533_ _03488_ VSS VSS VDD VDD _04131_ sky130_fd_sc_hd__nand2_1
X_09720_ _04131_ _03536_ VSS VSS VDD VDD _04132_ sky130_fd_sc_hd__nand2_2
X_09721_ _04130_ _04132_ VSS VSS VDD VDD _04134_ sky130_fd_sc_hd__nand2_1
X_09722_ _04125_ _04134_ VSS VSS VDD VDD _04135_ sky130_fd_sc_hd__nand2_1
X_09723_ _03953_ _04113_ VSS VSS VDD VDD _04136_ sky130_fd_sc_hd__nand2_1
X_09724_ _04029_ _04002_ VSS VSS VDD VDD _04137_ sky130_fd_sc_hd__nand2_1
X_09725_ _04136_ _04137_ VSS VSS VDD VDD _04138_ sky130_fd_sc_hd__nor2_2
X_09726_ _04135_ _04138_ VSS VSS VDD VDD _04139_ sky130_fd_sc_hd__nand2_2
X_09727_ _03999_ _03959_ VSS VSS VDD VDD _04140_ sky130_fd_sc_hd__nor2_1
X_09728_ _04052_ _04140_ _04047_ VSS VSS VDD VDD _04141_ sky130_fd_sc_hd__o21ai_1
X_09729_ _04108_ _04050_ VSS VSS VDD VDD _04142_ sky130_fd_sc_hd__nor2_2
X_09730_ _04107_ _03951_ _03883_ VSS VSS VDD VDD _04143_ sky130_fd_sc_hd__nand3_1
X_09731_ _04143_ _04101_ VSS VSS VDD VDD _04145_ sky130_fd_sc_hd__nand2_1
X_09732_ _04141_ _04142_ _04145_ VSS VSS VDD VDD _04146_ sky130_fd_sc_hd__a21oi_4
X_09733_ _04062_ _03832_ _04074_ VSS VSS VDD VDD _04147_ sky130_fd_sc_hd__nand3_1
X_09734_ _03832_ _04082_ _04147_ VSS VSS VDD VDD _04148_ sky130_fd_sc_hd__o21ai_0
X_09735_ _04077_ _04148_ VSS VSS VDD VDD _04149_ sky130_fd_sc_hd__xor2_1
X_09736_ _04087_ _03826_ VSS VSS VDD VDD _04150_ sky130_fd_sc_hd__nand2_1
X_09737_ _04094_ _03827_ VSS VSS VDD VDD _04151_ sky130_fd_sc_hd__nand2_1
X_09738_ _04150_ _04151_ VSS VSS VDD VDD _04152_ sky130_fd_sc_hd__nand2_1
X_09739_ _04149_ _04152_ VSS VSS VDD VDD _04153_ sky130_fd_sc_hd__xor2_1
X_09740_ _04153_ VSS VSS VDD VDD _04154_ sky130_fd_sc_hd__clkinv_1
X_09741_ _04139_ net67 _04146_ _04154_ VSS VSS VDD VDD _04156_
+ sky130_fd_sc_hd__nand4_1
X_09742_ _04116_ _04156_ VSS VSS VDD VDD _04157_ sky130_fd_sc_hd__nand2_1
X_09743_ _04039_ _04036_ VSS VSS VDD VDD _04158_ sky130_fd_sc_hd__nand2_1
X_09744_ _04053_ VSS VSS VDD VDD _04159_ sky130_fd_sc_hd__inv_1
X_09745_ _04117_ _04158_ _04159_ VSS VSS VDD VDD _04160_ sky130_fd_sc_hd__a21oi_1
X_09746_ _04121_ _04123_ _04160_ VSS VSS VDD VDD _04161_ sky130_fd_sc_hd__o21ai_0
X_09747_ _04161_ _04138_ VSS VSS VDD VDD _04162_ sky130_fd_sc_hd__nand2_1
X_09748_ _04138_ _04130_ _04132_ VSS VSS VDD VDD _04163_ sky130_fd_sc_hd__nand3_1
X_09749_ _04162_ _04163_ _04146_ _04154_ VSS VSS VDD VDD _04164_
+ sky130_fd_sc_hd__nand4_1
X_09750_ net67 VSS VSS VDD VDD _04165_ sky130_fd_sc_hd__inv_1
X_09751_ _04164_ _04165_ VSS VSS VDD VDD _04167_ sky130_fd_sc_hd__nand2_1
X_09752_ _04157_ _04167_ VSS VSS VDD VDD _04168_ sky130_fd_sc_hd__nand2_1
Xinput1 a_left[0] VSS VSS VDD VDD net1 sky130_fd_sc_hd__clkdlybuf4s50_1
X_09754_ net69 VSS VSS VDD VDD _04170_ sky130_fd_sc_hd__inv_1
X_09755_ _04164_ _04170_ VSS VSS VDD VDD _04171_ sky130_fd_sc_hd__nand2_1
X_09756_ _04139_ net69 _04146_ _04154_ VSS VSS VDD VDD _04172_
+ sky130_fd_sc_hd__nand4_1
X_09757_ _04171_ _04172_ VSS VSS VDD VDD _04173_ sky130_fd_sc_hd__nand2_2
X_09758_ net68 VSS VSS VDD VDD _04174_ sky130_fd_sc_hd__inv_1
X_09759_ _04164_ _04174_ VSS VSS VDD VDD _04175_ sky130_fd_sc_hd__nand2_2
X_09760_ _04139_ net68 _04146_ _04154_ VSS VSS VDD VDD _04176_
+ sky130_fd_sc_hd__nand4_1
X_09761_ _04175_ _04176_ VSS VSS VDD VDD _04178_ sky130_fd_sc_hd__nand2_2
X_09762_ _04173_ _04178_ VSS VSS VDD VDD _04179_ sky130_fd_sc_hd__nor2_1
X_09763_ _04179_ VSS VSS VDD VDD _04180_ sky130_fd_sc_hd__inv_1
X_09764_ _04172_ _04176_ VSS VSS VDD VDD _04181_ sky130_fd_sc_hd__nand2_1
X_09765_ _04168_ _04180_ _04181_ VSS VSS VDD VDD _04182_ sky130_fd_sc_hd__o21bai_1
X_09766_ net74 VSS VSS VDD VDD _04183_ sky130_fd_sc_hd__inv_1
X_09767_ _04164_ _04183_ VSS VSS VDD VDD _04184_ sky130_fd_sc_hd__nand2_1
X_09768_ _04139_ net74 _04146_ _04154_ VSS VSS VDD VDD _04185_
+ sky130_fd_sc_hd__nand4_1
X_09769_ _04184_ _04185_ VSS VSS VDD VDD _04186_ sky130_fd_sc_hd__nand2_1
X_09770_ _04186_ VSS VSS VDD VDD _04187_ sky130_fd_sc_hd__inv_1
X_09771_ net73 VSS VSS VDD VDD _04189_ sky130_fd_sc_hd__inv_1
X_09772_ _04164_ _04189_ VSS VSS VDD VDD _04190_ sky130_fd_sc_hd__nand2_1
X_09773_ _04139_ net73 _04146_ _04154_ VSS VSS VDD VDD _04191_
+ sky130_fd_sc_hd__nand4_1
X_09774_ _04190_ _04191_ VSS VSS VDD VDD _04192_ sky130_fd_sc_hd__nand2_1
X_09775_ _04192_ VSS VSS VDD VDD _04193_ sky130_fd_sc_hd__inv_1
X_09776_ _04187_ _04193_ VSS VSS VDD VDD _04194_ sky130_fd_sc_hd__nand2_1
X_09777_ net71 VSS VSS VDD VDD _04195_ sky130_fd_sc_hd__inv_1
X_09778_ _04164_ _04195_ VSS VSS VDD VDD _04196_ sky130_fd_sc_hd__nand2_1
X_09779_ _04139_ net71 _04146_ _04154_ VSS VSS VDD VDD _04197_
+ sky130_fd_sc_hd__nand4_1
X_09780_ _04196_ _04197_ VSS VSS VDD VDD _04198_ sky130_fd_sc_hd__nand2_1
X_09781_ _04198_ VSS VSS VDD VDD _04200_ sky130_fd_sc_hd__inv_1
X_09782_ net70 VSS VSS VDD VDD _04201_ sky130_fd_sc_hd__inv_1
X_09783_ _04164_ _04201_ VSS VSS VDD VDD _04202_ sky130_fd_sc_hd__nand2_1
X_09784_ _04139_ net70 _04146_ _04154_ VSS VSS VDD VDD _04203_
+ sky130_fd_sc_hd__nand4_1
X_09785_ _04202_ _04203_ VSS VSS VDD VDD _04204_ sky130_fd_sc_hd__nand2_1
X_09786_ _04204_ VSS VSS VDD VDD _04205_ sky130_fd_sc_hd__inv_1
X_09787_ _04200_ _04205_ VSS VSS VDD VDD _04206_ sky130_fd_sc_hd__nand2_1
X_09788_ _04194_ _04206_ VSS VSS VDD VDD _04207_ sky130_fd_sc_hd__nor2_1
X_09789_ _04164_ VSS VSS VDD VDD _04208_ sky130_fd_sc_hd__inv_1
X_09790_ net70 net71 net73 net74 _04208_ VSS VSS VDD VDD _04209_
+ sky130_fd_sc_hd__o41ai_1
X_09791_ _04182_ _04207_ _04209_ VSS VSS VDD VDD _04211_ sky130_fd_sc_hd__a21boi_1
X_09792_ _03542_ _04128_ VSS VSS VDD VDD _04212_ sky130_fd_sc_hd__nand2_1
X_09793_ _03534_ _03541_ _03642_ VSS VSS VDD VDD _04213_ sky130_fd_sc_hd__nand3_1
X_09794_ _04212_ _04213_ VSS VSS VDD VDD _04214_ sky130_fd_sc_hd__nand2_1
X_09795_ net83 VSS VSS VDD VDD _04215_ sky130_fd_sc_hd__inv_1
X_09796_ _04214_ _04215_ VSS VSS VDD VDD _04216_ sky130_fd_sc_hd__nand2_1
X_09797_ _04212_ _04213_ net83 VSS VSS VDD VDD _04217_ sky130_fd_sc_hd__nand3_1
X_09798_ _04216_ _04217_ VSS VSS VDD VDD _04218_ sky130_fd_sc_hd__nand2_1
X_09799_ _04132_ _04128_ _03443_ VSS VSS VDD VDD _04219_ sky130_fd_sc_hd__nand3_1
X_09800_ _04219_ _04121_ VSS VSS VDD VDD _04220_ sky130_fd_sc_hd__nand2_1
X_09801_ _04220_ _03728_ VSS VSS VDD VDD _04222_ sky130_fd_sc_hd__nand2_1
X_09802_ _04219_ _03729_ _04121_ VSS VSS VDD VDD _04223_ sky130_fd_sc_hd__nand3_1
X_09803_ _04222_ _04223_ VSS VSS VDD VDD _04224_ sky130_fd_sc_hd__nand2_1
X_09804_ _04224_ net84 VSS VSS VDD VDD _04225_ sky130_fd_sc_hd__nand2_1
X_09805_ net84 VSS VSS VDD VDD _04226_ sky130_fd_sc_hd__inv_1
X_09806_ _04222_ _04226_ _04223_ VSS VSS VDD VDD _04227_ sky130_fd_sc_hd__nand3_1
X_09807_ _04225_ _04227_ VSS VSS VDD VDD _04228_ sky130_fd_sc_hd__nand2_1
X_09808_ _03530_ _03481_ _03487_ _03532_ VSS VSS VDD VDD _04229_
+ sky130_fd_sc_hd__nand4_1
X_09809_ _04229_ _04131_ VSS VSS VDD VDD _04230_ sky130_fd_sc_hd__nand2_1
X_09810_ _04230_ VSS VSS VDD VDD _04231_ sky130_fd_sc_hd__inv_1
X_09811_ net81 _04231_ VSS VSS VDD VDD _04233_ sky130_fd_sc_hd__nor2_1
X_09812_ _03491_ _03492_ _03489_ VSS VSS VDD VDD _04234_ sky130_fd_sc_hd__nand3_1
X_09813_ _03479_ _04234_ VSS VSS VDD VDD _04235_ sky130_fd_sc_hd__nand2_1
X_09814_ _04235_ _03531_ VSS VSS VDD VDD _04236_ sky130_fd_sc_hd__nand2_1
X_09815_ _03494_ _03511_ VSS VSS VDD VDD _04237_ sky130_fd_sc_hd__nand2_1
X_09816_ _04236_ _04237_ VSS VSS VDD VDD _04238_ sky130_fd_sc_hd__nand2_1
X_09817_ _03512_ _03511_ VSS VSS VDD VDD _04239_ sky130_fd_sc_hd__nand2_1
X_09818_ _03527_ _04239_ VSS VSS VDD VDD _04240_ sky130_fd_sc_hd__nor2_1
X_09819_ _04240_ VSS VSS VDD VDD _04241_ sky130_fd_sc_hd__inv_1
X_09820_ _04238_ _04241_ VSS VSS VDD VDD _04242_ sky130_fd_sc_hd__nand2_1
X_09821_ _04236_ _04237_ _04240_ VSS VSS VDD VDD _04244_ sky130_fd_sc_hd__nand3_1
X_09822_ net80 _04242_ _04244_ VSS VSS VDD VDD _04245_ sky130_fd_sc_hd__nand3b_1
X_09823_ net78 VSS VSS VDD VDD _04246_ sky130_fd_sc_hd__inv_1
X_09824_ _03513_ _03522_ _03525_ VSS VSS VDD VDD _04247_ sky130_fd_sc_hd__nand3_1
X_09825_ _03527_ _04247_ VSS VSS VDD VDD _04248_ sky130_fd_sc_hd__nand2_1
X_09826_ _04246_ _04248_ VSS VSS VDD VDD _04249_ sky130_fd_sc_hd__xor2_1
X_09827_ net77 VSS VSS VDD VDD _04250_ sky130_fd_sc_hd__inv_1
X_09828_ _03523_ _03458_ VSS VSS VDD VDD _04251_ sky130_fd_sc_hd__nand2_1
X_09829_ _03525_ _04251_ VSS VSS VDD VDD _04252_ sky130_fd_sc_hd__nand2_1
X_09830_ net72 VSS VSS VDD VDD _04253_ sky130_fd_sc_hd__inv_1
X_09831_ wrapped_design.b1_skew\[1\] wrapped_design.a00_right\[0\]
+ VSS VSS VDD VDD _04255_ sky130_fd_sc_hd__nand2_1
X_09832_ _00713_ _03547_ _04255_ VSS VSS VDD VDD _04256_ sky130_fd_sc_hd__o21ai_0
X_09833_ _04256_ _03519_ VSS VSS VDD VDD _04257_ sky130_fd_sc_hd__nand2_1
X_09834_ _04253_ _04257_ VSS VSS VDD VDD _04258_ sky130_fd_sc_hd__nor2_1
X_09835_ net61 VSS VSS VDD VDD _04259_ sky130_fd_sc_hd__inv_1
X_09836_ _04257_ VSS VSS VDD VDD _04260_ sky130_fd_sc_hd__inv_1
X_09837_ net72 _04260_ VSS VSS VDD VDD _04261_ sky130_fd_sc_hd__nor2_1
X_09838_ _04259_ _03516_ _04258_ _04261_ VSS VSS VDD VDD _04262_
+ sky130_fd_sc_hd__nor4_1
X_09839_ _04250_ _04252_ VSS VSS VDD VDD _04263_ sky130_fd_sc_hd__nor2_1
X_09840_ _03525_ _04251_ net77 VSS VSS VDD VDD _04264_ sky130_fd_sc_hd__a21oi_1
X_09841_ _04263_ _04264_ VSS VSS VDD VDD _04266_ sky130_fd_sc_hd__nor2_1
X_09842_ _04258_ _04262_ _04266_ VSS VSS VDD VDD _04267_ sky130_fd_sc_hd__o21ai_0
X_09843_ _04250_ _04252_ _04267_ VSS VSS VDD VDD _04268_ sky130_fd_sc_hd__o21ai_0
X_09844_ _04249_ _04268_ VSS VSS VDD VDD _04269_ sky130_fd_sc_hd__nand2_1
X_09845_ _04246_ _04248_ _04269_ VSS VSS VDD VDD _04270_ sky130_fd_sc_hd__o21ai_0
X_09846_ _04239_ _03527_ VSS VSS VDD VDD _04271_ sky130_fd_sc_hd__nand2_1
X_09847_ _04241_ _04271_ VSS VSS VDD VDD _04272_ sky130_fd_sc_hd__nand2_1
X_09848_ net79 VSS VSS VDD VDD _04273_ sky130_fd_sc_hd__inv_1
X_09849_ _04272_ _04273_ VSS VSS VDD VDD _04274_ sky130_fd_sc_hd__nand2_1
X_09850_ _04270_ _04274_ VSS VSS VDD VDD _04275_ sky130_fd_sc_hd__nand2_1
X_09851_ _04272_ VSS VSS VDD VDD _04277_ sky130_fd_sc_hd__inv_1
X_09852_ _04277_ net79 VSS VSS VDD VDD _04278_ sky130_fd_sc_hd__nand2_1
X_09853_ _04275_ _04278_ VSS VSS VDD VDD _04279_ sky130_fd_sc_hd__nand2_1
X_09854_ _04245_ _04279_ VSS VSS VDD VDD _04280_ sky130_fd_sc_hd__nand2_1
X_09855_ _04242_ _04244_ VSS VSS VDD VDD _04281_ sky130_fd_sc_hd__nand2_1
X_09856_ _04281_ net80 VSS VSS VDD VDD _04282_ sky130_fd_sc_hd__nand2_1
X_09857_ _04280_ _04282_ VSS VSS VDD VDD _04283_ sky130_fd_sc_hd__nand2_1
X_09858_ net81 VSS VSS VDD VDD _04284_ sky130_fd_sc_hd__inv_1
X_09859_ _04284_ _04230_ VSS VSS VDD VDD _04285_ sky130_fd_sc_hd__nor2_1
X_09860_ _04283_ _04285_ VSS VSS VDD VDD _04286_ sky130_fd_sc_hd__nor2_1
X_09861_ _04233_ _04286_ VSS VSS VDD VDD _04288_ sky130_fd_sc_hd__nor2_1
X_09862_ _03443_ VSS VSS VDD VDD _04289_ sky130_fd_sc_hd__inv_1
X_09863_ _04132_ _04289_ VSS VSS VDD VDD _04290_ sky130_fd_sc_hd__nand2_1
X_09864_ net82 VSS VSS VDD VDD _04291_ sky130_fd_sc_hd__inv_1
X_09865_ _04131_ _03536_ _03443_ VSS VSS VDD VDD _04292_ sky130_fd_sc_hd__nand3_1
X_09866_ _04290_ _04291_ _04292_ VSS VSS VDD VDD _04293_ sky130_fd_sc_hd__nand3_1
X_09867_ _04288_ _04293_ VSS VSS VDD VDD _04294_ sky130_fd_sc_hd__nand2_1
X_09868_ _04290_ _04292_ VSS VSS VDD VDD _04295_ sky130_fd_sc_hd__nand2_1
X_09869_ _04295_ net82 VSS VSS VDD VDD _04296_ sky130_fd_sc_hd__nand2_1
X_09870_ _04294_ _04296_ VSS VSS VDD VDD _04297_ sky130_fd_sc_hd__nand2_1
X_09871_ _04228_ _04297_ VSS VSS VDD VDD _04299_ sky130_fd_sc_hd__nand2_1
X_09872_ _04218_ _04299_ VSS VSS VDD VDD _04300_ sky130_fd_sc_hd__nor2_1
X_09873_ _04135_ _04029_ VSS VSS VDD VDD _04301_ sky130_fd_sc_hd__nand2_1
X_09874_ _04029_ _04125_ _04134_ VSS VSS VDD VDD _04302_ sky130_fd_sc_hd__nand3b_1
X_09875_ _04301_ _04302_ VSS VSS VDD VDD _04303_ sky130_fd_sc_hd__nand2_1
X_09876_ net63 VSS VSS VDD VDD _04304_ sky130_fd_sc_hd__inv_1
X_09877_ _04303_ _04304_ VSS VSS VDD VDD _04305_ sky130_fd_sc_hd__nand2_1
X_09878_ _04301_ _04302_ net63 VSS VSS VDD VDD _04306_ sky130_fd_sc_hd__nand3_1
X_09879_ _04305_ _04306_ VSS VSS VDD VDD _04307_ sky130_fd_sc_hd__nand2_1
X_09880_ _04307_ VSS VSS VDD VDD _04308_ sky130_fd_sc_hd__inv_2
X_09881_ _04042_ VSS VSS VDD VDD _04310_ sky130_fd_sc_hd__inv_1
X_09882_ _03740_ _04310_ VSS VSS VDD VDD _04311_ sky130_fd_sc_hd__nand2_1
X_09883_ _03731_ _04042_ _03739_ VSS VSS VDD VDD _04312_ sky130_fd_sc_hd__nand3_1
X_09884_ _04311_ net62 _04312_ VSS VSS VDD VDD _04313_ sky130_fd_sc_hd__nand3_1
X_09885_ _03740_ _04042_ VSS VSS VDD VDD _04314_ sky130_fd_sc_hd__nand2_1
X_09886_ net62 VSS VSS VDD VDD _04315_ sky130_fd_sc_hd__inv_1
X_09887_ _03731_ _04310_ _03739_ VSS VSS VDD VDD _04316_ sky130_fd_sc_hd__nand3_1
X_09888_ _04314_ _04315_ _04316_ VSS VSS VDD VDD _04317_ sky130_fd_sc_hd__nand3_1
X_09889_ _04313_ _04317_ VSS VSS VDD VDD _04318_ sky130_fd_sc_hd__nand2_1
X_09890_ _04300_ _04308_ _04318_ VSS VSS VDD VDD _04319_ sky130_fd_sc_hd__nand3_1
X_09891_ _04222_ net84 _04223_ VSS VSS VDD VDD _04321_ sky130_fd_sc_hd__nand3_1
X_09892_ _04321_ _04217_ VSS VSS VDD VDD _04322_ sky130_fd_sc_hd__nand2_1
X_09893_ _04224_ _04226_ VSS VSS VDD VDD _04323_ sky130_fd_sc_hd__nand2_1
X_09894_ _04322_ _04323_ VSS VSS VDD VDD _04324_ sky130_fd_sc_hd__nand2_1
X_09895_ _04324_ _04308_ _04318_ VSS VSS VDD VDD _04325_ sky130_fd_sc_hd__nand3b_1
X_09896_ _04314_ net62 _04316_ VSS VSS VDD VDD _04326_ sky130_fd_sc_hd__nand3_1
X_09897_ _04306_ _04326_ VSS VSS VDD VDD _04327_ sky130_fd_sc_hd__nand2_1
X_09898_ _04327_ _04305_ VSS VSS VDD VDD _04328_ sky130_fd_sc_hd__nand2_1
X_09899_ _04319_ _04325_ _04328_ VSS VSS VDD VDD _04329_ sky130_fd_sc_hd__nand3_2
X_09900_ _04057_ _03739_ VSS VSS VDD VDD _04330_ sky130_fd_sc_hd__nand2_1
X_09901_ _04330_ VSS VSS VDD VDD _04332_ sky130_fd_sc_hd__inv_1
X_09902_ _03731_ _04332_ VSS VSS VDD VDD _04333_ sky130_fd_sc_hd__nand2_1
X_09903_ _04043_ _04057_ VSS VSS VDD VDD _04334_ sky130_fd_sc_hd__nand2_1
X_09904_ _04333_ _04334_ VSS VSS VDD VDD _04335_ sky130_fd_sc_hd__nand2_1
X_09905_ _04335_ _04002_ VSS VSS VDD VDD _04336_ sky130_fd_sc_hd__nand2_1
X_09906_ _04002_ VSS VSS VDD VDD _04337_ sky130_fd_sc_hd__inv_1
X_09907_ _04333_ _04337_ _04334_ VSS VSS VDD VDD _04338_ sky130_fd_sc_hd__nand3_1
X_09908_ _04336_ _04338_ VSS VSS VDD VDD _04339_ sky130_fd_sc_hd__nand2_1
X_09909_ net64 _04339_ VSS VSS VDD VDD _04340_ sky130_fd_sc_hd__nor2_1
X_09910_ _04340_ VSS VSS VDD VDD _04341_ sky130_fd_sc_hd__inv_1
X_09911_ _04339_ net64 VSS VSS VDD VDD _04343_ sky130_fd_sc_hd__nand2_1
X_09912_ _04341_ _04343_ VSS VSS VDD VDD _04344_ sky130_fd_sc_hd__nand2_1
X_09913_ _04123_ _04137_ VSS VSS VDD VDD _04345_ sky130_fd_sc_hd__nor2_1
X_09914_ _03488_ _04238_ VSS VSS VDD VDD _04346_ sky130_fd_sc_hd__nand2_1
X_09915_ _04346_ _04129_ VSS VSS VDD VDD _04347_ sky130_fd_sc_hd__nor2_1
X_09916_ _04345_ _04240_ _04347_ VSS VSS VDD VDD _04348_ sky130_fd_sc_hd__nand3_1
X_09917_ _04137_ _04160_ VSS VSS VDD VDD _04349_ sky130_fd_sc_hd__nor2_1
X_09918_ _04141_ _04349_ VSS VSS VDD VDD _04350_ sky130_fd_sc_hd__nor2_1
X_09919_ _03480_ _03485_ VSS VSS VDD VDD _04351_ sky130_fd_sc_hd__nor2_1
X_09920_ _03532_ _04351_ _03536_ VSS VSS VDD VDD _04352_ sky130_fd_sc_hd__o21ai_0
X_09921_ _04352_ _04128_ _03443_ VSS VSS VDD VDD _04354_ sky130_fd_sc_hd__nand3_1
X_09922_ _04354_ _04121_ VSS VSS VDD VDD _04355_ sky130_fd_sc_hd__nand2_1
X_09923_ _04355_ _04345_ VSS VSS VDD VDD _04356_ sky130_fd_sc_hd__nand2_1
X_09924_ _04348_ _04350_ _04356_ VSS VSS VDD VDD _04357_ sky130_fd_sc_hd__nand3_1
X_09925_ _04357_ _04050_ VSS VSS VDD VDD _04358_ sky130_fd_sc_hd__nand2_1
X_09926_ _04348_ _04350_ _03953_ _04356_ VSS VSS VDD VDD _04359_
+ sky130_fd_sc_hd__nand4_1
X_09927_ net65 _04358_ _04359_ VSS VSS VDD VDD _04360_ sky130_fd_sc_hd__nand3b_1
X_09928_ _04357_ _03953_ VSS VSS VDD VDD _04361_ sky130_fd_sc_hd__nand2_1
X_09929_ _04348_ _04350_ _04356_ _04050_ VSS VSS VDD VDD _04362_
+ sky130_fd_sc_hd__nand4_1
X_09930_ _04361_ _04362_ net65 VSS VSS VDD VDD _04363_ sky130_fd_sc_hd__nand3_1
X_09931_ _04360_ _04363_ VSS VSS VDD VDD _04365_ sky130_fd_sc_hd__nand2_1
X_09932_ _04344_ _04365_ VSS VSS VDD VDD _04366_ sky130_fd_sc_hd__nor2_1
X_09933_ _04329_ _04366_ VSS VSS VDD VDD _04367_ sky130_fd_sc_hd__nand2_1
X_09934_ _04363_ _04343_ VSS VSS VDD VDD _04368_ sky130_fd_sc_hd__nand2_1
X_09935_ _04368_ _04360_ VSS VSS VDD VDD _04369_ sky130_fd_sc_hd__nand2_1
X_09936_ _04367_ _04369_ VSS VSS VDD VDD _04370_ sky130_fd_sc_hd__nand2_1
X_09937_ _04167_ _04156_ VSS VSS VDD VDD _04371_ sky130_fd_sc_hd__nand2_1
X_09938_ _04060_ _04113_ VSS VSS VDD VDD _04372_ sky130_fd_sc_hd__nand2_1
X_09939_ _04046_ _04108_ _04059_ VSS VSS VDD VDD _04373_ sky130_fd_sc_hd__nand3_1
X_09940_ _04372_ _04373_ VSS VSS VDD VDD _04374_ sky130_fd_sc_hd__nand2_1
X_09941_ net66 VSS VSS VDD VDD _04376_ sky130_fd_sc_hd__inv_1
X_09942_ _04374_ _04376_ VSS VSS VDD VDD _04377_ sky130_fd_sc_hd__nand2_1
X_09943_ _04377_ _04116_ VSS VSS VDD VDD _04378_ sky130_fd_sc_hd__nand2_1
X_09944_ _04371_ _04378_ VSS VSS VDD VDD _04379_ sky130_fd_sc_hd__nor2_2
X_09945_ _04379_ _04179_ VSS VSS VDD VDD _04380_ sky130_fd_sc_hd__nand2_1
X_09946_ _04194_ _04206_ _04380_ VSS VSS VDD VDD _04381_ sky130_fd_sc_hd__nor3_1
X_09947_ _04370_ _04381_ VSS VSS VDD VDD _04382_ sky130_fd_sc_hd__nand2_1
X_09948_ _04211_ _04382_ VSS VSS VDD VDD _04383_ sky130_fd_sc_hd__nand2_1
X_09949_ net75 VSS VSS VDD VDD _04384_ sky130_fd_sc_hd__inv_1
X_09950_ _04164_ _04384_ VSS VSS VDD VDD _04385_ sky130_fd_sc_hd__nand2_1
X_09951_ _04139_ net75 _04146_ _04154_ VSS VSS VDD VDD _04387_
+ sky130_fd_sc_hd__nand4_1
X_09952_ _04385_ _04387_ VSS VSS VDD VDD _04388_ sky130_fd_sc_hd__nand2_1
X_09953_ _04388_ VSS VSS VDD VDD _04389_ sky130_fd_sc_hd__inv_1
X_09954_ _04383_ _04389_ VSS VSS VDD VDD _04390_ sky130_fd_sc_hd__nand2_1
X_09955_ _04211_ _04382_ _04388_ VSS VSS VDD VDD _04391_ sky130_fd_sc_hd__nand3_1
X_09956_ _04390_ _04391_ net154 VSS VSS VDD VDD _04392_ sky130_fd_sc_hd__nand3_1
X_09957_ net154 _04164_ VSS VSS VDD VDD _04393_ sky130_fd_sc_hd__nor2_1
X_09958_ net153 _04393_ VSS VSS VDD VDD _04394_ sky130_fd_sc_hd__nor2_1
X_09959_ net156 net75 net160 VSS VSS VDD VDD _04395_ sky130_fd_sc_hd__o21ai_0
X_09960_ _04392_ _04394_ _04395_ VSS VSS VDD VDD _00111_ sky130_fd_sc_hd__a21oi_1
X_09961_ _04217_ _04296_ VSS VSS VDD VDD _04397_ sky130_fd_sc_hd__nand2_1
X_09962_ _04397_ _04216_ VSS VSS VDD VDD _04398_ sky130_fd_sc_hd__nand2_1
X_09963_ _04398_ VSS VSS VDD VDD _04399_ sky130_fd_sc_hd__inv_1
X_09964_ _04318_ _04399_ _04228_ VSS VSS VDD VDD _04400_ sky130_fd_sc_hd__nand3_1
X_09965_ _04295_ _04291_ VSS VSS VDD VDD _04401_ sky130_fd_sc_hd__nand2_1
X_09966_ _04290_ net82 _04292_ VSS VSS VDD VDD _04402_ sky130_fd_sc_hd__nand3_1
X_09967_ _04401_ _04402_ VSS VSS VDD VDD _04403_ sky130_fd_sc_hd__nand2_1
X_09968_ _04288_ _04403_ VSS VSS VDD VDD _04404_ sky130_fd_sc_hd__nand2_1
X_09969_ _04218_ _04404_ VSS VSS VDD VDD _04405_ sky130_fd_sc_hd__nor2_2
X_09970_ _04318_ _04405_ _04228_ VSS VSS VDD VDD _04406_ sky130_fd_sc_hd__nand3_1
X_09971_ _04326_ _04321_ VSS VSS VDD VDD _04408_ sky130_fd_sc_hd__nand2_1
X_09972_ _04314_ _04316_ VSS VSS VDD VDD _04409_ sky130_fd_sc_hd__nand2_1
X_09973_ _04409_ _04315_ VSS VSS VDD VDD _04410_ sky130_fd_sc_hd__nand2_1
X_09974_ _04408_ _04410_ VSS VSS VDD VDD _04411_ sky130_fd_sc_hd__nand2_1
X_09975_ _04400_ _04406_ _04411_ VSS VSS VDD VDD _04412_ sky130_fd_sc_hd__nand3_1
X_09976_ _04307_ _04344_ VSS VSS VDD VDD _04413_ sky130_fd_sc_hd__nor2_1
X_09977_ _04412_ _04413_ VSS VSS VDD VDD _04414_ sky130_fd_sc_hd__nand2_1
X_09978_ _04343_ _04306_ _04340_ VSS VSS VDD VDD _04415_ sky130_fd_sc_hd__a21oi_1
X_09979_ _04415_ VSS VSS VDD VDD _04416_ sky130_fd_sc_hd__inv_1
X_09980_ _04414_ _04416_ VSS VSS VDD VDD _04417_ sky130_fd_sc_hd__nand2_1
X_09981_ _04178_ _04371_ VSS VSS VDD VDD _04419_ sky130_fd_sc_hd__nor2_2
X_09982_ _04419_ VSS VSS VDD VDD _04420_ sky130_fd_sc_hd__inv_1
X_09983_ _04374_ net66 VSS VSS VDD VDD _04421_ sky130_fd_sc_hd__nand2_1
X_09984_ _04115_ _04376_ VSS VSS VDD VDD _04422_ sky130_fd_sc_hd__nand2_1
X_09985_ _04421_ _04422_ VSS VSS VDD VDD _04423_ sky130_fd_sc_hd__nand2_1
X_09986_ _04423_ _04360_ _04363_ VSS VSS VDD VDD _04424_ sky130_fd_sc_hd__nand3_1
X_09987_ _04420_ _04424_ VSS VSS VDD VDD _04425_ sky130_fd_sc_hd__nor2_1
X_09988_ _04192_ _04198_ VSS VSS VDD VDD _04426_ sky130_fd_sc_hd__nor2_1
X_09989_ _04204_ _04173_ VSS VSS VDD VDD _04427_ sky130_fd_sc_hd__nor2_1
X_09990_ _04426_ _04427_ VSS VSS VDD VDD _04428_ sky130_fd_sc_hd__and2_1
X_09991_ _04417_ _04425_ _04428_ VSS VSS VDD VDD _04430_ sky130_fd_sc_hd__nand3_1
X_09992_ _04363_ _04116_ VSS VSS VDD VDD _04431_ sky130_fd_sc_hd__nand2_1
X_09993_ _04419_ _04377_ _04431_ VSS VSS VDD VDD _04432_ sky130_fd_sc_hd__nand3_1
X_09994_ net67 net68 _04208_ VSS VSS VDD VDD _04433_ sky130_fd_sc_hd__o21ai_0
X_09995_ _04432_ _04433_ VSS VSS VDD VDD _04434_ sky130_fd_sc_hd__nand2_1
X_09996_ _04434_ _04428_ VSS VSS VDD VDD _04435_ sky130_fd_sc_hd__nand2_1
X_09997_ net69 net70 net71 net73 _04208_ VSS VSS VDD VDD _04436_
+ sky130_fd_sc_hd__o41ai_1
X_09998_ _04430_ _04435_ _04436_ VSS VSS VDD VDD _04437_ sky130_fd_sc_hd__nand3_1
X_09999_ _04437_ _04187_ VSS VSS VDD VDD _04438_ sky130_fd_sc_hd__nand2_1
X_10000_ _04430_ _04435_ _04186_ _04436_ VSS VSS VDD VDD _04439_
+ sky130_fd_sc_hd__nand4_1
X_10001_ _04438_ _04439_ net154 VSS VSS VDD VDD _04441_ sky130_fd_sc_hd__nand3_1
X_10002_ net156 net74 net160 VSS VSS VDD VDD _04442_ sky130_fd_sc_hd__o21ai_0
X_10003_ _04441_ _04394_ _04442_ VSS VSS VDD VDD _00112_ sky130_fd_sc_hd__a21oi_1
X_10004_ _04206_ _04180_ VSS VSS VDD VDD _04443_ sky130_fd_sc_hd__nor2_1
X_10005_ _04329_ _04443_ _04379_ _04366_ VSS VSS VDD VDD _04444_
+ sky130_fd_sc_hd__nand4_1
X_10006_ net68 net69 net70 net71 _04208_ VSS VSS VDD VDD _04445_
+ sky130_fd_sc_hd__o41ai_1
X_10007_ _04371_ VSS VSS VDD VDD _04446_ sky130_fd_sc_hd__inv_1
X_10008_ _04423_ _04446_ VSS VSS VDD VDD _04447_ sky130_fd_sc_hd__nand2_1
X_10009_ _04369_ _04447_ _04168_ VSS VSS VDD VDD _04448_ sky130_fd_sc_hd__o21ai_1
X_10010_ _04448_ _04443_ VSS VSS VDD VDD _04449_ sky130_fd_sc_hd__nand2_1
X_10011_ _04444_ _04445_ _04449_ VSS VSS VDD VDD _04451_ sky130_fd_sc_hd__nand3_1
X_10012_ _04451_ _04193_ VSS VSS VDD VDD _04452_ sky130_fd_sc_hd__nand2_1
X_10013_ _04444_ _04449_ _04192_ _04445_ VSS VSS VDD VDD _04453_
+ sky130_fd_sc_hd__nand4_1
X_10014_ _04452_ _04453_ net154 VSS VSS VDD VDD _04454_ sky130_fd_sc_hd__nand3_1
X_10015_ net156 net73 net160 VSS VSS VDD VDD _04455_ sky130_fd_sc_hd__o21ai_0
X_10016_ _04454_ _04394_ _04455_ VSS VSS VDD VDD _00113_ sky130_fd_sc_hd__a21oi_1
X_10017_ _04431_ _04377_ _04415_ VSS VSS VDD VDD _04456_ sky130_fd_sc_hd__a21oi_1
X_10018_ _04456_ _04414_ VSS VSS VDD VDD _04457_ sky130_fd_sc_hd__nand2_2
X_10019_ _04431_ _04377_ VSS VSS VDD VDD _04458_ sky130_fd_sc_hd__nand2_1
X_10020_ _04424_ _04458_ VSS VSS VDD VDD _04459_ sky130_fd_sc_hd__nand2_1
X_10021_ _04457_ _04427_ _04419_ _04459_ VSS VSS VDD VDD _04461_
+ sky130_fd_sc_hd__nand4_1
X_10022_ net67 net68 net69 net70 _04208_ VSS VSS VDD VDD _04462_
+ sky130_fd_sc_hd__o41ai_1
X_10023_ _04461_ _04462_ VSS VSS VDD VDD _04463_ sky130_fd_sc_hd__nand2_1
X_10024_ _04463_ _04200_ VSS VSS VDD VDD _04464_ sky130_fd_sc_hd__nand2_1
X_10025_ _04461_ _04198_ _04462_ VSS VSS VDD VDD _04465_ sky130_fd_sc_hd__nand3_1
X_10026_ _04464_ net154 _04465_ VSS VSS VDD VDD _04466_ sky130_fd_sc_hd__nand3_1
X_10027_ net156 net71 net160 VSS VSS VDD VDD _04467_ sky130_fd_sc_hd__o21ai_0
X_10028_ _04466_ _04394_ _04467_ VSS VSS VDD VDD _00114_ sky130_fd_sc_hd__a21oi_1
X_10029_ _04380_ VSS VSS VDD VDD _04468_ sky130_fd_sc_hd__inv_1
X_10030_ _04370_ _04468_ VSS VSS VDD VDD _04469_ sky130_fd_sc_hd__nand2_1
X_10031_ _04182_ VSS VSS VDD VDD _04471_ sky130_fd_sc_hd__inv_1
X_10032_ _04469_ _04471_ VSS VSS VDD VDD _04472_ sky130_fd_sc_hd__nand2_1
X_10033_ _04472_ _04205_ VSS VSS VDD VDD _04473_ sky130_fd_sc_hd__nand2_1
X_10034_ _04469_ _04204_ _04471_ VSS VSS VDD VDD _04474_ sky130_fd_sc_hd__nand3_1
X_10035_ _04473_ net154 _04474_ VSS VSS VDD VDD _04475_ sky130_fd_sc_hd__nand3_1
X_10036_ net156 net70 net160 VSS VSS VDD VDD _04476_ sky130_fd_sc_hd__o21ai_0
X_10037_ _04475_ _04394_ _04476_ VSS VSS VDD VDD _00115_ sky130_fd_sc_hd__a21oi_1
X_10038_ _04417_ _04425_ VSS VSS VDD VDD _04477_ sky130_fd_sc_hd__nand2_1
X_10039_ _04477_ _04433_ _04432_ VSS VSS VDD VDD _04478_ sky130_fd_sc_hd__nand3_1
X_10040_ _04478_ _04172_ _04171_ VSS VSS VDD VDD _04479_ sky130_fd_sc_hd__nand3_1
X_10041_ _04477_ _04173_ _04433_ _04432_ VSS VSS VDD VDD _04481_
+ sky130_fd_sc_hd__nand4_1
X_10042_ _04479_ _04481_ net154 VSS VSS VDD VDD _04482_ sky130_fd_sc_hd__nand3_1
X_10043_ net156 net69 net160 VSS VSS VDD VDD _04483_ sky130_fd_sc_hd__o21ai_0
X_10044_ _04482_ _04394_ _04483_ VSS VSS VDD VDD _00116_ sky130_fd_sc_hd__a21oi_1
X_10045_ _04178_ VSS VSS VDD VDD _04484_ sky130_fd_sc_hd__inv_1
X_10046_ _04329_ _04379_ _04366_ VSS VSS VDD VDD _04485_ sky130_fd_sc_hd__nand3_1
X_10047_ _04448_ VSS VSS VDD VDD _04486_ sky130_fd_sc_hd__inv_1
X_10048_ _04485_ _04486_ VSS VSS VDD VDD _04487_ sky130_fd_sc_hd__nand2_1
X_10049_ _04487_ _04484_ net158 VSS VSS VDD VDD _04488_ sky130_fd_sc_hd__a21oi_1
X_10050_ _04484_ _04487_ _04488_ VSS VSS VDD VDD _04489_ sky130_fd_sc_hd__o21ai_0
X_10051_ net156 net68 net160 VSS VSS VDD VDD _04491_ sky130_fd_sc_hd__o21ai_0
X_10052_ _04489_ _04394_ _04491_ VSS VSS VDD VDD _00117_ sky130_fd_sc_hd__a21oi_1
X_10053_ _04457_ _04459_ VSS VSS VDD VDD _04492_ sky130_fd_sc_hd__nand2_1
X_10054_ _04492_ _04371_ VSS VSS VDD VDD _04493_ sky130_fd_sc_hd__nand2_1
X_10055_ _04457_ _04446_ _04459_ VSS VSS VDD VDD _04494_ sky130_fd_sc_hd__nand3_1
X_10056_ _04493_ net154 _04494_ VSS VSS VDD VDD _04495_ sky130_fd_sc_hd__nand3_1
X_10057_ net156 net67 net160 VSS VSS VDD VDD _04496_ sky130_fd_sc_hd__o21ai_0
X_10058_ _04495_ _04394_ _04496_ VSS VSS VDD VDD _00118_ sky130_fd_sc_hd__a21oi_1
X_10059_ _04367_ _04369_ _04423_ VSS VSS VDD VDD _04497_ sky130_fd_sc_hd__a21oi_1
X_10060_ _04378_ _04370_ net154 VSS VSS VDD VDD _04498_ sky130_fd_sc_hd__o21ai_1
X_10061_ _04374_ net158 net153 VSS VSS VDD VDD _04500_ sky130_fd_sc_hd__a21oi_1
X_10062_ _04497_ _04498_ _04500_ VSS VSS VDD VDD _04501_ sky130_fd_sc_hd__o21ai_1
X_10063_ net153 net66 VSS VSS VDD VDD _04502_ sky130_fd_sc_hd__nand2_1
X_10064_ _04501_ _04502_ net164 VSS VSS VDD VDD _00119_ sky130_fd_sc_hd__a21oi_1
X_10065_ _04358_ _04359_ net153 VSS VSS VDD VDD _04503_ sky130_fd_sc_hd__a21oi_1
X_10066_ _04414_ _04416_ _04365_ VSS VSS VDD VDD _04504_ sky130_fd_sc_hd__a21oi_1
X_10067_ _04360_ _04363_ _04417_ VSS VSS VDD VDD _04505_ sky130_fd_sc_hd__a21oi_1
X_10068_ _04504_ _04505_ net154 VSS VSS VDD VDD _04506_ sky130_fd_sc_hd__o21ai_0
X_10069_ net152 _04503_ _04506_ VSS VSS VDD VDD _04507_ sky130_fd_sc_hd__o21ai_0
X_10070_ net153 net65 VSS VSS VDD VDD _04508_ sky130_fd_sc_hd__nand2_1
X_10071_ _04507_ _04508_ net164 VSS VSS VDD VDD _00120_ sky130_fd_sc_hd__a21oi_1
X_10072_ _04344_ _04329_ VSS VSS VDD VDD _04510_ sky130_fd_sc_hd__xor2_1
X_10073_ _04510_ net154 VSS VSS VDD VDD _04511_ sky130_fd_sc_hd__nand2_1
X_10074_ net154 _04339_ net157 _04511_ VSS VSS VDD VDD _04512_
+ sky130_fd_sc_hd__o211ai_1
X_10075_ net153 net64 VSS VSS VDD VDD _04513_ sky130_fd_sc_hd__nand2_1
X_10076_ _04512_ _04513_ net164 VSS VSS VDD VDD _00121_ sky130_fd_sc_hd__a21oi_1
X_10077_ _04412_ _04308_ net152 VSS VSS VDD VDD _04514_ sky130_fd_sc_hd__a21boi_0
X_10078_ _04308_ _04412_ _04514_ VSS VSS VDD VDD _04515_ sky130_fd_sc_hd__o21ai_0
X_10079_ net157 _04304_ _03134_ _04303_ VSS VSS VDD VDD _04516_
+ sky130_fd_sc_hd__o22ai_1
X_10080_ _04516_ VSS VSS VDD VDD _04517_ sky130_fd_sc_hd__inv_1
X_10081_ _04515_ _04517_ net164 VSS VSS VDD VDD _00122_ sky130_fd_sc_hd__a21oi_1
X_10082_ _04218_ _04299_ _04324_ VSS VSS VDD VDD _04519_ sky130_fd_sc_hd__o21ai_0
X_10083_ _04519_ _04318_ net152 VSS VSS VDD VDD _04520_ sky130_fd_sc_hd__a21boi_0
X_10084_ _04318_ _04519_ _04520_ VSS VSS VDD VDD _04521_ sky130_fd_sc_hd__o21ai_0
X_10085_ net157 _04315_ _03134_ _04409_ VSS VSS VDD VDD _04522_
+ sky130_fd_sc_hd__o22ai_1
X_10086_ _04522_ VSS VSS VDD VDD _04523_ sky130_fd_sc_hd__inv_1
X_10087_ _04521_ _04523_ net164 VSS VSS VDD VDD _00123_ sky130_fd_sc_hd__a21oi_1
X_10088_ _04399_ _04405_ _04228_ VSS VSS VDD VDD _04524_ sky130_fd_sc_hd__nor3_1
X_10089_ _04399_ _04405_ _04228_ VSS VSS VDD VDD _04525_ sky130_fd_sc_hd__o21ai_0
X_10090_ _04524_ net152 _04525_ VSS VSS VDD VDD _04526_ sky130_fd_sc_hd__nand3b_1
X_10091_ net157 _04226_ _03134_ _04224_ VSS VSS VDD VDD _04528_
+ sky130_fd_sc_hd__o22ai_1
X_10092_ _04528_ VSS VSS VDD VDD _04529_ sky130_fd_sc_hd__inv_1
X_10093_ _04526_ _04529_ net164 VSS VSS VDD VDD _00124_ sky130_fd_sc_hd__a21oi_1
X_10094_ _04218_ _04297_ VSS VSS VDD VDD _04530_ sky130_fd_sc_hd__xnor2_1
X_10095_ _04530_ net152 VSS VSS VDD VDD _04531_ sky130_fd_sc_hd__nand2_1
X_10096_ net157 _04215_ _03134_ _04214_ VSS VSS VDD VDD _04532_
+ sky130_fd_sc_hd__o22ai_1
X_10097_ _04532_ VSS VSS VDD VDD _04533_ sky130_fd_sc_hd__inv_1
X_10098_ _04531_ _04533_ net164 VSS VSS VDD VDD _00125_ sky130_fd_sc_hd__a21oi_1
X_10099_ _04403_ _04288_ VSS VSS VDD VDD _04534_ sky130_fd_sc_hd__xor2_1
X_10100_ _04290_ _04292_ net158 net153 VSS VSS VDD VDD _04535_
+ sky130_fd_sc_hd__a31oi_1
X_10101_ net158 _04534_ _04535_ VSS VSS VDD VDD _04537_ sky130_fd_sc_hd__o21ai_0
X_10102_ net153 net82 VSS VSS VDD VDD _04538_ sky130_fd_sc_hd__nand2_1
X_10103_ _04537_ _04538_ net164 VSS VSS VDD VDD _00126_ sky130_fd_sc_hd__a21oi_1
X_10104_ _04285_ _04233_ VSS VSS VDD VDD _04539_ sky130_fd_sc_hd__nor2_1
X_10105_ _04539_ _04283_ net158 VSS VSS VDD VDD _04540_ sky130_fd_sc_hd__a21oi_1
X_10106_ _04283_ _04539_ _04540_ VSS VSS VDD VDD _04541_ sky130_fd_sc_hd__o21ai_0
X_10107_ _04231_ net158 VSS VSS VDD VDD _04542_ sky130_fd_sc_hd__nand2_1
X_10108_ net156 net81 net160 VSS VSS VDD VDD _04543_ sky130_fd_sc_hd__o21ai_0
X_10109_ _04541_ net156 _04542_ _04543_ VSS VSS VDD VDD _00127_
+ sky130_fd_sc_hd__a31oi_1
X_10110_ _04282_ _04245_ VSS VSS VDD VDD _04544_ sky130_fd_sc_hd__nand2_1
X_10111_ _04279_ _04544_ VSS VSS VDD VDD _04546_ sky130_fd_sc_hd__nor2_1
X_10112_ _04544_ _04279_ VSS VSS VDD VDD _04547_ sky130_fd_sc_hd__nand2_1
X_10113_ _04547_ net154 VSS VSS VDD VDD _04548_ sky130_fd_sc_hd__nand2_1
X_10114_ net154 _04281_ _04546_ _04548_ net156 VSS VSS VDD
+ VDD _04549_ sky130_fd_sc_hd__o221ai_1
X_10115_ net153 net80 VSS VSS VDD VDD _04550_ sky130_fd_sc_hd__nand2_1
X_10116_ _04549_ _04550_ net164 VSS VSS VDD VDD _00128_ sky130_fd_sc_hd__a21oi_1
X_10117_ _04278_ _04274_ _04270_ VSS VSS VDD VDD _04551_ sky130_fd_sc_hd__a21oi_1
X_10118_ net79 _04277_ _04275_ VSS VSS VDD VDD _04552_ sky130_fd_sc_hd__a21oi_1
X_10119_ net158 _04551_ _04552_ VSS VSS VDD VDD _04553_ sky130_fd_sc_hd__or3_1
X_10120_ _04277_ net158 VSS VSS VDD VDD _04554_ sky130_fd_sc_hd__nand2_1
X_10121_ net156 net79 net160 VSS VSS VDD VDD _04556_ sky130_fd_sc_hd__o21ai_0
X_10122_ _04553_ net156 _04554_ _04556_ VSS VSS VDD VDD _00129_
+ sky130_fd_sc_hd__a31oi_1
X_10123_ _04268_ _04249_ VSS VSS VDD VDD _04557_ sky130_fd_sc_hd__or2_2
X_10124_ _04557_ net152 _04269_ VSS VSS VDD VDD _04558_ sky130_fd_sc_hd__nand3_1
X_10125_ net156 _04246_ _03134_ _04248_ VSS VSS VDD VDD _04559_
+ sky130_fd_sc_hd__o22ai_1
X_10126_ _04559_ VSS VSS VDD VDD _04560_ sky130_fd_sc_hd__inv_1
X_10127_ _04558_ _04560_ net164 VSS VSS VDD VDD _00130_ sky130_fd_sc_hd__a21oi_1
X_10128_ net156 _04250_ _03134_ _04252_ VSS VSS VDD VDD _04561_
+ sky130_fd_sc_hd__o22ai_1
X_10129_ _04258_ _04262_ _04266_ VSS VSS VDD VDD _04562_ sky130_fd_sc_hd__nor3_1
X_10130_ _04267_ net152 VSS VSS VDD VDD _04563_ sky130_fd_sc_hd__nand2_1
X_10131_ _04562_ _04563_ VSS VSS VDD VDD _04565_ sky130_fd_sc_hd__nor2_1
X_10132_ _04561_ _04565_ net160 VSS VSS VDD VDD _00131_ sky130_fd_sc_hd__o21a_1
X_10133_ _04259_ _03516_ _04258_ _04261_ VSS VSS VDD VDD _04566_
+ sky130_fd_sc_hd__o22ai_1
X_10134_ _04262_ net154 _04566_ VSS VSS VDD VDD _04567_ sky130_fd_sc_hd__nand3b_1
X_10135_ _04260_ net158 net153 VSS VSS VDD VDD _04568_ sky130_fd_sc_hd__a21oi_1
X_10136_ net153 _04253_ _04567_ _04568_ net164 VSS VSS VDD
+ VDD _00132_ sky130_fd_sc_hd__a221oi_1
X_10137_ net153 _03516_ _04259_ _03135_ VSS VSS VDD VDD _04569_
+ sky130_fd_sc_hd__o22ai_1
X_10138_ _04569_ net160 VSS VSS VDD VDD _04570_ sky130_fd_sc_hd__nand2_1
X_10139_ net156 net61 _03134_ _03521_ _04570_ VSS VSS VDD
+ VDD _00133_ sky130_fd_sc_hd__a41oi_1
X_10140_ net164 _00486_ VSS VSS VDD VDD _00134_ sky130_fd_sc_hd__nor2_1
X_10141_ net155 wrapped_design.l10 VSS VSS VDD VDD _04572_
+ sky130_fd_sc_hd__nand2_1
X_10142_ net164 _04572_ VSS VSS VDD VDD _00135_ sky130_fd_sc_hd__nor2_1
X_10143_ _00508_ _00514_ VSS VSS VDD VDD _04573_ sky130_fd_sc_hd__nand2_1
X_10144_ _00322_ _00478_ VSS VSS VDD VDD _04574_ sky130_fd_sc_hd__nor2_1
X_10145_ _00513_ _04574_ VSS VSS VDD VDD _04575_ sky130_fd_sc_hd__nand2_1
X_10146_ _04573_ _04575_ VSS VSS VDD VDD _04576_ sky130_fd_sc_hd__nor2_1
X_10147_ _00548_ _04576_ _00550_ VSS VSS VDD VDD _04577_ sky130_fd_sc_hd__nand3_1
X_10148_ net119 net121 net122 net123 _00331_ VSS VSS VDD VDD
+ _04578_ sky130_fd_sc_hd__o41ai_1
X_10149_ _00552_ _04575_ _04578_ VSS VSS VDD VDD _04579_ sky130_fd_sc_hd__o21a_1
X_10150_ net124 VSS VSS VDD VDD _04580_ sky130_fd_sc_hd__inv_1
X_10151_ _04577_ _04579_ _04580_ VSS VSS VDD VDD _04582_ sky130_fd_sc_hd__a21oi_1
X_10152_ _04577_ _04580_ _04579_ VSS VSS VDD VDD _04583_ sky130_fd_sc_hd__nand3_2
X_10153_ _04583_ _00482_ VSS VSS VDD VDD _04584_ sky130_fd_sc_hd__nand2_1
X_10154_ _04582_ _04584_ VSS VSS VDD VDD _04585_ sky130_fd_sc_hd__nor2_1
X_10155_ _00487_ _04585_ VSS VSS VDD VDD _04586_ sky130_fd_sc_hd__nor2_1
X_10156_ _04577_ _04579_ VSS VSS VDD VDD _04587_ sky130_fd_sc_hd__nand2_1
X_10157_ _04587_ net124 VSS VSS VDD VDD _04588_ sky130_fd_sc_hd__nand2_1
X_10158_ _00486_ _00289_ VSS VSS VDD VDD _04589_ sky130_fd_sc_hd__nor2_1
X_10159_ _04588_ _04583_ _00482_ _04589_ VSS VSS VDD VDD _04590_
+ sky130_fd_sc_hd__nand4_1
X_10160_ _04580_ _00486_ net164 VSS VSS VDD VDD _04591_ sky130_fd_sc_hd__a21oi_1
X_10161_ _04590_ _04591_ VSS VSS VDD VDD _04593_ sky130_fd_sc_hd__nand2_1
X_10162_ _04586_ _04593_ VSS VSS VDD VDD _00136_ sky130_fd_sc_hd__nor2_1
X_10163_ net7 _00664_ VSS VSS VDD VDD _04594_ sky130_fd_sc_hd__nor2_1
X_10164_ net163 wrapped_design.a1_skew\[7\] net161 VSS VSS
+ VDD VDD _04595_ sky130_fd_sc_hd__o21ai_0
X_10165_ _04594_ _04595_ VSS VSS VDD VDD _00137_ sky130_fd_sc_hd__nor2_1
X_10166_ net23 net159 net160 VSS VSS VDD VDD _04596_ sky130_fd_sc_hd__o21ai_0
X_10167_ _03235_ net159 _04596_ VSS VSS VDD VDD _00138_ sky130_fd_sc_hd__a21oi_1
X_10168_ net164 net153 VSS VSS VDD VDD _00139_ sky130_fd_sc_hd__nor2_1
X_10169_ net164 _03134_ VSS VSS VDD VDD _00140_ sky130_fd_sc_hd__nor2_1
X_10170_ net156 wrapped_design.l00 VSS VSS VDD VDD _04597_
+ sky130_fd_sc_hd__nand2_1
X_10171_ net164 _04597_ VSS VSS VDD VDD _00141_ sky130_fd_sc_hd__nor2_1
X_10172_ wrapped_design.a1_skew\[7\] net153 VSS VSS VDD VDD
+ _04599_ sky130_fd_sc_hd__nor2_1
X_10173_ net156 wrapped_design.a10_right\[7\] net160 VSS VSS
+ VDD VDD _04600_ sky130_fd_sc_hd__o21ai_0
X_10174_ _04599_ _04600_ VSS VSS VDD VDD _00142_ sky130_fd_sc_hd__nor2_1
X_10175_ _01764_ _01759_ VSS VSS VDD VDD _04601_ sky130_fd_sc_hd__nand2_1
X_10176_ _01746_ _01580_ VSS VSS VDD VDD _04602_ sky130_fd_sc_hd__nor2_1
X_10177_ _01763_ _04602_ VSS VSS VDD VDD _04603_ sky130_fd_sc_hd__nand2_1
X_10178_ _04601_ _04603_ VSS VSS VDD VDD _04604_ sky130_fd_sc_hd__nor2_1
X_10179_ _01816_ _04604_ _01817_ VSS VSS VDD VDD _04605_ sky130_fd_sc_hd__nand3_1
X_10180_ net47 net49 net50 net51 _01589_ VSS VSS VDD VDD _04606_
+ sky130_fd_sc_hd__o41ai_1
X_10181_ _01819_ _04603_ _04606_ VSS VSS VDD VDD _04608_ sky130_fd_sc_hd__o21a_1
X_10182_ _04605_ _04608_ VSS VSS VDD VDD _04609_ sky130_fd_sc_hd__nand2_1
X_10183_ _04609_ net52 VSS VSS VDD VDD _04610_ sky130_fd_sc_hd__nand2_1
X_10184_ _04610_ VSS VSS VDD VDD _04611_ sky130_fd_sc_hd__inv_1
X_10185_ net52 VSS VSS VDD VDD _04612_ sky130_fd_sc_hd__inv_1
X_10186_ _04605_ _04612_ _04608_ VSS VSS VDD VDD _04613_ sky130_fd_sc_hd__nand3_1
X_10187_ _04613_ _01749_ VSS VSS VDD VDD _04614_ sky130_fd_sc_hd__nand2_1
X_10188_ _04611_ _04614_ VSS VSS VDD VDD _04615_ sky130_fd_sc_hd__nor2_1
X_10189_ _01754_ _04615_ VSS VSS VDD VDD _04616_ sky130_fd_sc_hd__nor2_1
X_10190_ net159 _01548_ VSS VSS VDD VDD _04617_ sky130_fd_sc_hd__nor2_1
X_10191_ _04610_ _04613_ _01749_ _04617_ VSS VSS VDD VDD _04619_
+ sky130_fd_sc_hd__nand4_1
X_10192_ net159 _04612_ net34 VSS VSS VDD VDD _04620_ sky130_fd_sc_hd__a21oi_1
X_10193_ _04619_ _04620_ VSS VSS VDD VDD _04621_ sky130_fd_sc_hd__nand2_1
X_10194_ _04616_ _04621_ VSS VSS VDD VDD _00143_ sky130_fd_sc_hd__nor2_1
X_10195_ _03053_ _02975_ VSS VSS VDD VDD _04622_ sky130_fd_sc_hd__nand2_1
X_10196_ _02828_ _02961_ VSS VSS VDD VDD _04623_ sky130_fd_sc_hd__nor2_1
X_10197_ _02832_ _02838_ VSS VSS VDD VDD _04624_ sky130_fd_sc_hd__nor2_1
X_10198_ _04623_ _04624_ VSS VSS VDD VDD _04625_ sky130_fd_sc_hd__nand2_1
X_10199_ _04622_ _04625_ VSS VSS VDD VDD _04626_ sky130_fd_sc_hd__nor2_1
X_10200_ _03051_ _03054_ _04626_ VSS VSS VDD VDD _04627_ sky130_fd_sc_hd__nand3_1
X_10201_ net95 net97 net98 net99 _02889_ VSS VSS VDD VDD _04629_
+ sky130_fd_sc_hd__o41ai_1
X_10202_ _03056_ _04625_ _04629_ VSS VSS VDD VDD _04630_ sky130_fd_sc_hd__o21a_1
X_10203_ _04627_ _04630_ VSS VSS VDD VDD _04631_ sky130_fd_sc_hd__nand2_1
X_10204_ _04631_ net100 VSS VSS VDD VDD _04632_ sky130_fd_sc_hd__nand2_1
X_10205_ net100 VSS VSS VDD VDD _04633_ sky130_fd_sc_hd__inv_1
X_10206_ _04627_ _04633_ _04630_ VSS VSS VDD VDD _04634_ sky130_fd_sc_hd__nand3_1
X_10207_ _04632_ net154 _04634_ VSS VSS VDD VDD _04635_ sky130_fd_sc_hd__nand3_1
X_10208_ _02972_ _04635_ VSS VSS VDD VDD _04636_ sky130_fd_sc_hd__nor2b_1
X_10209_ net153 _02822_ VSS VSS VDD VDD _04637_ sky130_fd_sc_hd__nor2_1
X_10210_ _04632_ _04634_ net154 _04637_ VSS VSS VDD VDD _04638_
+ sky130_fd_sc_hd__nand4_1
X_10211_ net153 _04633_ net164 VSS VSS VDD VDD _04640_ sky130_fd_sc_hd__a21oi_1
X_10212_ _04638_ _04640_ VSS VSS VDD VDD _04641_ sky130_fd_sc_hd__nand2_1
X_10213_ _04636_ _04641_ VSS VSS VDD VDD _00144_ sky130_fd_sc_hd__nor2_1
X_10214_ net163 wrapped_design.b00_down\[7\] net161 VSS VSS
+ VDD VDD _04642_ sky130_fd_sc_hd__o21ai_0
X_10215_ net163 _00729_ _04642_ VSS VSS VDD VDD _00145_ sky130_fd_sc_hd__a21oi_1
X_10216_ net14 net159 VSS VSS VDD VDD _04643_ sky130_fd_sc_hd__nor2_1
X_10217_ wrapped_design.a00_right\[7\] net163 net160 VSS VSS
+ VDD VDD _04644_ sky130_fd_sc_hd__o21ai_0
X_10218_ _04643_ _04644_ VSS VSS VDD VDD _00146_ sky130_fd_sc_hd__nor2_1
X_10219_ net162 net33 VSS VSS VDD VDD _04645_ sky130_fd_sc_hd__nand2_1
X_10220_ net164 _04645_ VSS VSS VDD VDD _00147_ sky130_fd_sc_hd__nor2_1
X_10221_ net34 _01859_ VSS VSS VDD VDD _00148_ sky130_fd_sc_hd__nor2_1
X_10222_ net164 net159 VSS VSS VDD VDD _00149_ sky130_fd_sc_hd__nor2_1
X_10223_ net156 wrapped_design.b01_down\[7\] net160 VSS VSS
+ VDD VDD _04647_ sky130_fd_sc_hd__o21ai_0
X_10224_ net156 _03235_ _04647_ VSS VSS VDD VDD _00150_ sky130_fd_sc_hd__a21oi_1
X_10225_ _04427_ _04419_ VSS VSS VDD VDD _04648_ sky130_fd_sc_hd__nand2_1
X_10226_ _04186_ _04388_ VSS VSS VDD VDD _04649_ sky130_fd_sc_hd__nor2_1
X_10227_ _04426_ _04649_ VSS VSS VDD VDD _04650_ sky130_fd_sc_hd__nand2_1
X_10228_ _04648_ _04650_ VSS VSS VDD VDD _04651_ sky130_fd_sc_hd__nor2_1
X_10229_ _04457_ _04651_ _04459_ VSS VSS VDD VDD _04652_ sky130_fd_sc_hd__nand3_1
X_10230_ net71 net73 net74 net75 _04208_ VSS VSS VDD VDD _04653_
+ sky130_fd_sc_hd__o41ai_1
X_10231_ _04462_ _04650_ _04653_ VSS VSS VDD VDD _04655_ sky130_fd_sc_hd__o21a_1
X_10232_ _04652_ _04655_ VSS VSS VDD VDD _04656_ sky130_fd_sc_hd__nand2_1
X_10233_ net76 _04164_ VSS VSS VDD VDD _04657_ sky130_fd_sc_hd__xnor2_1
X_10234_ _04657_ VSS VSS VDD VDD _04658_ sky130_fd_sc_hd__inv_1
X_10235_ _04656_ _04658_ VSS VSS VDD VDD _04659_ sky130_fd_sc_hd__nand2_1
X_10236_ _04652_ _04655_ _04657_ VSS VSS VDD VDD _04660_ sky130_fd_sc_hd__nand3_1
X_10237_ _04659_ _04660_ VSS VSS VDD VDD _04661_ sky130_fd_sc_hd__nand2_1
X_10238_ _04661_ net154 VSS VSS VDD VDD _04662_ sky130_fd_sc_hd__nand2_1
X_10239_ _04393_ VSS VSS VDD VDD _04663_ sky130_fd_sc_hd__inv_1
X_10240_ _04662_ net156 _04663_ VSS VSS VDD VDD _04664_ sky130_fd_sc_hd__nand3_1
X_10241_ net76 net156 VSS VSS VDD VDD _04666_ sky130_fd_sc_hd__nor2_1
X_10242_ net164 _04666_ VSS VSS VDD VDD _04667_ sky130_fd_sc_hd__nor2_1
X_10243_ _04664_ _04667_ VSS VSS VDD VDD _04668_ sky130_fd_sc_hd__nand2_1
X_10244_ _04668_ VSS VSS VDD VDD _00151_ sky130_fd_sc_hd__inv_1
X_10245_ wrapped_design.pe11.valid_out wrapped_design.l11
+ VSS VSS VDD VDD _04669_ sky130_fd_sc_hd__nand2_1
X_10246_ _04669_ VSS VSS VDD VDD net133 sky130_fd_sc_hd__inv_1
Xwrapped_design.a1_skew\[0\]$_SDFFE_PP0P_ clknet_4_8_0_clk
+ _00029_ VSS VSS VDD VDD wrapped_design.a1_skew\[0\] sky130_fd_sc_hd__dfxtp_1
Xwrapped_design.a1_skew\[1\]$_SDFFE_PP0P_ clknet_4_8_0_clk
+ _00028_ VSS VSS VDD VDD wrapped_design.a1_skew\[1\] sky130_fd_sc_hd__dfxtp_1
Xwrapped_design.a1_skew\[2\]$_SDFFE_PP0P_ clknet_4_8_0_clk
+ _00027_ VSS VSS VDD VDD wrapped_design.a1_skew\[2\] sky130_fd_sc_hd__dfxtp_1
Xwrapped_design.a1_skew\[3\]$_SDFFE_PP0P_ clknet_4_8_0_clk
+ _00026_ VSS VSS VDD VDD wrapped_design.a1_skew\[3\] sky130_fd_sc_hd__dfxtp_1
Xwrapped_design.a1_skew\[4\]$_SDFFE_PP0P_ clknet_4_11_0_clk
+ _00025_ VSS VSS VDD VDD wrapped_design.a1_skew\[4\] sky130_fd_sc_hd__dfxtp_1
Xwrapped_design.a1_skew\[5\]$_SDFFE_PP0P_ clknet_4_11_0_clk
+ _00024_ VSS VSS VDD VDD wrapped_design.a1_skew\[5\] sky130_fd_sc_hd__dfxtp_1
Xwrapped_design.a1_skew\[6\]$_SDFFE_PP0P_ clknet_4_9_0_clk
+ _00023_ VSS VSS VDD VDD wrapped_design.a1_skew\[6\] sky130_fd_sc_hd__dfxtp_1
Xwrapped_design.a1_skew\[7\]$_SDFFE_PP0P_ clknet_4_1_0_clk
+ _00137_ VSS VSS VDD VDD wrapped_design.a1_skew\[7\] sky130_fd_sc_hd__dfxtp_1
Xwrapped_design.b1_skew\[0\]$_SDFFE_PP0P_ clknet_4_11_0_clk
+ _00036_ VSS VSS VDD VDD wrapped_design.b1_skew\[0\] sky130_fd_sc_hd__dfxtp_1
Xwrapped_design.b1_skew\[1\]$_SDFFE_PP0P_ clknet_4_11_0_clk
+ _00035_ VSS VSS VDD VDD wrapped_design.b1_skew\[1\] sky130_fd_sc_hd__dfxtp_1
Xwrapped_design.b1_skew\[2\]$_SDFFE_PP0P_ clknet_4_9_0_clk
+ _00034_ VSS VSS VDD VDD wrapped_design.b1_skew\[2\] sky130_fd_sc_hd__dfxtp_1
Xwrapped_design.b1_skew\[3\]$_SDFFE_PP0P_ clknet_4_8_0_clk
+ _00033_ VSS VSS VDD VDD wrapped_design.b1_skew\[3\] sky130_fd_sc_hd__dfxtp_1
Xwrapped_design.b1_skew\[4\]$_SDFFE_PP0P_ clknet_4_9_0_clk
+ _00032_ VSS VSS VDD VDD wrapped_design.b1_skew\[4\] sky130_fd_sc_hd__dfxtp_1
Xwrapped_design.b1_skew\[5\]$_SDFFE_PP0P_ clknet_4_8_0_clk
+ _00031_ VSS VSS VDD VDD wrapped_design.b1_skew\[5\] sky130_fd_sc_hd__dfxtp_1
Xwrapped_design.b1_skew\[6\]$_SDFFE_PP0P_ clknet_4_8_0_clk
+ _00030_ VSS VSS VDD VDD wrapped_design.b1_skew\[6\] sky130_fd_sc_hd__dfxtp_1
Xwrapped_design.b1_skew\[7\]$_SDFFE_PP0P_ clknet_4_11_0_clk
+ _00138_ VSS VSS VDD VDD wrapped_design.b1_skew\[7\] sky130_fd_sc_hd__dfxtp_1
Xwrapped_design.pe00.a_out\[0\]$_SDFFE_PP0P_ clknet_4_9_0_clk
+ _00103_ VSS VSS VDD VDD wrapped_design.a00_right\[0\] sky130_fd_sc_hd__dfxtp_1
Xwrapped_design.pe00.a_out\[1\]$_SDFFE_PP0P_ clknet_4_3_0_clk
+ _00102_ VSS VSS VDD VDD wrapped_design.a00_right\[1\] sky130_fd_sc_hd__dfxtp_1
Xwrapped_design.pe00.a_out\[2\]$_SDFFE_PP0P_ clknet_4_9_0_clk
+ _00101_ VSS VSS VDD VDD wrapped_design.a00_right\[2\] sky130_fd_sc_hd__dfxtp_1
Xwrapped_design.pe00.a_out\[3\]$_SDFFE_PP0P_ clknet_4_9_0_clk
+ _00100_ VSS VSS VDD VDD wrapped_design.a00_right\[3\] sky130_fd_sc_hd__dfxtp_1
Xwrapped_design.pe00.a_out\[4\]$_SDFFE_PP0P_ clknet_4_9_0_clk
+ _00099_ VSS VSS VDD VDD wrapped_design.a00_right\[4\] sky130_fd_sc_hd__dfxtp_1
Xwrapped_design.pe00.a_out\[5\]$_SDFFE_PP0P_ clknet_4_3_0_clk
+ _00098_ VSS VSS VDD VDD wrapped_design.a00_right\[5\] sky130_fd_sc_hd__dfxtp_1
Xwrapped_design.pe00.a_out\[6\]$_SDFFE_PP0P_ clknet_4_11_0_clk
+ _00097_ VSS VSS VDD VDD wrapped_design.a00_right\[6\] sky130_fd_sc_hd__dfxtp_1
Xwrapped_design.pe00.a_out\[7\]$_SDFFE_PP0P_ clknet_4_9_0_clk
+ _00146_ VSS VSS VDD VDD wrapped_design.a00_right\[7\] sky130_fd_sc_hd__dfxtp_1
Xwrapped_design.pe00.acc_out\[0\]$_SDFFE_PP0P_ clknet_4_4_0_clk
+ _00066_ VSS VSS VDD VDD net37 sky130_fd_sc_hd__dfxtp_1
Xwrapped_design.pe00.acc_out\[10\]$_SDFFE_PP0P_ clknet_4_5_0_clk
+ _00056_ VSS VSS VDD VDD net38 sky130_fd_sc_hd__dfxtp_1
Xwrapped_design.pe00.acc_out\[11\]$_SDFFE_PP0P_ clknet_4_5_0_clk
+ _00055_ VSS VSS VDD VDD net39 sky130_fd_sc_hd__dfxtp_1
Xwrapped_design.pe00.acc_out\[12\]$_SDFFE_PP0P_ clknet_4_4_0_clk
+ _00054_ VSS VSS VDD VDD net40 sky130_fd_sc_hd__dfxtp_1
Xwrapped_design.pe00.acc_out\[13\]$_SDFFE_PP0P_ clknet_4_5_0_clk
+ _00053_ VSS VSS VDD VDD net41 sky130_fd_sc_hd__dfxtp_1
Xwrapped_design.pe00.acc_out\[14\]$_SDFFE_PP0P_ clknet_4_5_0_clk
+ _00052_ VSS VSS VDD VDD net42 sky130_fd_sc_hd__dfxtp_1
Xwrapped_design.pe00.acc_out\[15\]$_SDFFE_PP0P_ clknet_4_5_0_clk
+ _00051_ VSS VSS VDD VDD net43 sky130_fd_sc_hd__dfxtp_1
Xwrapped_design.pe00.acc_out\[16\]$_SDFFE_PP0P_ clknet_4_5_0_clk
+ _00050_ VSS VSS VDD VDD net44 sky130_fd_sc_hd__dfxtp_1
Xwrapped_design.pe00.acc_out\[17\]$_SDFFE_PP0P_ clknet_4_7_0_clk
+ _00049_ VSS VSS VDD VDD net45 sky130_fd_sc_hd__dfxtp_1
Xwrapped_design.pe00.acc_out\[18\]$_SDFFE_PP0P_ clknet_4_6_0_clk
+ _00048_ VSS VSS VDD VDD net46 sky130_fd_sc_hd__dfxtp_1
Xwrapped_design.pe00.acc_out\[19\]$_SDFFE_PP0P_ clknet_4_7_0_clk
+ _00047_ VSS VSS VDD VDD net47 sky130_fd_sc_hd__dfxtp_1
Xwrapped_design.pe00.acc_out\[1\]$_SDFFE_PP0P_ clknet_4_4_0_clk
+ _00065_ VSS VSS VDD VDD net48 sky130_fd_sc_hd__dfxtp_1
Xwrapped_design.pe00.acc_out\[20\]$_SDFFE_PP0P_ clknet_4_7_0_clk
+ _00046_ VSS VSS VDD VDD net49 sky130_fd_sc_hd__dfxtp_1
Xwrapped_design.pe00.acc_out\[21\]$_SDFFE_PP0P_ clknet_4_7_0_clk
+ _00045_ VSS VSS VDD VDD net50 sky130_fd_sc_hd__dfxtp_1
Xwrapped_design.pe00.acc_out\[22\]$_SDFFE_PP0P_ clknet_4_6_0_clk
+ _00044_ VSS VSS VDD VDD net51 sky130_fd_sc_hd__dfxtp_1
Xwrapped_design.pe00.acc_out\[23\]$_SDFFE_PP0P_ clknet_4_5_0_clk
+ _00143_ VSS VSS VDD VDD net52 sky130_fd_sc_hd__dfxtp_1
Xwrapped_design.pe00.acc_out\[2\]$_SDFFE_PP0P_ clknet_4_4_0_clk
+ _00064_ VSS VSS VDD VDD net53 sky130_fd_sc_hd__dfxtp_1
Xwrapped_design.pe00.acc_out\[3\]$_SDFFE_PP0P_ clknet_4_4_0_clk
+ _00063_ VSS VSS VDD VDD net54 sky130_fd_sc_hd__dfxtp_1
Xwrapped_design.pe00.acc_out\[4\]$_SDFFE_PP0P_ clknet_4_5_0_clk
+ _00062_ VSS VSS VDD VDD net55 sky130_fd_sc_hd__dfxtp_1
Xwrapped_design.pe00.acc_out\[5\]$_SDFFE_PP0P_ clknet_4_5_0_clk
+ _00061_ VSS VSS VDD VDD net56 sky130_fd_sc_hd__dfxtp_1
Xwrapped_design.pe00.acc_out\[6\]$_SDFFE_PP0P_ clknet_4_4_0_clk
+ _00060_ VSS VSS VDD VDD net57 sky130_fd_sc_hd__dfxtp_1
Xwrapped_design.pe00.acc_out\[7\]$_SDFFE_PP0P_ clknet_4_4_0_clk
+ _00059_ VSS VSS VDD VDD net58 sky130_fd_sc_hd__dfxtp_1
Xwrapped_design.pe00.acc_out\[8\]$_SDFFE_PP0P_ clknet_4_5_0_clk
+ _00058_ VSS VSS VDD VDD net59 sky130_fd_sc_hd__dfxtp_1
Xwrapped_design.pe00.acc_out\[9\]$_SDFFE_PP0P_ clknet_4_4_0_clk
+ _00057_ VSS VSS VDD VDD net60 sky130_fd_sc_hd__dfxtp_1
Xwrapped_design.pe00.b_out\[0\]$_SDFFE_PP0P_ clknet_4_2_0_clk
+ _00096_ VSS VSS VDD VDD wrapped_design.b00_down\[0\] sky130_fd_sc_hd__dfxtp_1
Xwrapped_design.pe00.b_out\[1\]$_SDFFE_PP0P_ clknet_4_2_0_clk
+ _00095_ VSS VSS VDD VDD wrapped_design.b00_down\[1\] sky130_fd_sc_hd__dfxtp_1
Xwrapped_design.pe00.b_out\[2\]$_SDFFE_PP0P_ clknet_4_0_0_clk
+ _00094_ VSS VSS VDD VDD wrapped_design.b00_down\[2\] sky130_fd_sc_hd__dfxtp_1
Xwrapped_design.pe00.b_out\[3\]$_SDFFE_PP0P_ clknet_4_1_0_clk
+ _00093_ VSS VSS VDD VDD wrapped_design.b00_down\[3\] sky130_fd_sc_hd__dfxtp_1
Xwrapped_design.pe00.b_out\[4\]$_SDFFE_PP0P_ clknet_4_1_0_clk
+ _00092_ VSS VSS VDD VDD wrapped_design.b00_down\[4\] sky130_fd_sc_hd__dfxtp_1
Xwrapped_design.pe00.b_out\[5\]$_SDFFE_PP0P_ clknet_4_2_0_clk
+ _00091_ VSS VSS VDD VDD wrapped_design.b00_down\[5\] sky130_fd_sc_hd__dfxtp_1
Xwrapped_design.pe00.b_out\[6\]$_SDFFE_PP0P_ clknet_4_2_0_clk
+ _00090_ VSS VSS VDD VDD wrapped_design.b00_down\[6\] sky130_fd_sc_hd__dfxtp_1
Xwrapped_design.pe00.b_out\[7\]$_SDFFE_PP0P_ clknet_4_3_0_clk
+ _00145_ VSS VSS VDD VDD wrapped_design.b00_down\[7\] sky130_fd_sc_hd__dfxtp_1
Xwrapped_design.pe00.last_out$_SDFF_PP0_ clknet_4_7_0_clk
+ _00147_ VSS VSS VDD VDD wrapped_design.l00 sky130_fd_sc_hd__dfxtp_1
Xwrapped_design.pe00.start_out$_SDFF_PP0_ clknet_4_1_0_clk
+ _00148_ VSS VSS VDD VDD wrapped_design.pe00.start_out sky130_fd_sc_hd__dfxtp_1
Xwrapped_design.pe00.valid_out$_SDFF_PP0_ clknet_4_11_0_clk
+ _00149_ VSS VSS VDD VDD wrapped_design.pe00.valid_out sky130_fd_sc_hd__dfxtp_1
Xwrapped_design.pe01.acc_out\[0\]$_SDFFE_PP0P_ clknet_4_9_0_clk
+ _00133_ VSS VSS VDD VDD net61 sky130_fd_sc_hd__dfxtp_1
Xwrapped_design.pe01.acc_out\[10\]$_SDFFE_PP0P_ clknet_4_10_0_clk
+ _00123_ VSS VSS VDD VDD net62 sky130_fd_sc_hd__dfxtp_1
Xwrapped_design.pe01.acc_out\[11\]$_SDFFE_PP0P_ clknet_4_10_0_clk
+ _00122_ VSS VSS VDD VDD net63 sky130_fd_sc_hd__dfxtp_1
Xwrapped_design.pe01.acc_out\[12\]$_SDFFE_PP0P_ clknet_4_10_0_clk
+ _00121_ VSS VSS VDD VDD net64 sky130_fd_sc_hd__dfxtp_1
Xwrapped_design.pe01.acc_out\[13\]$_SDFFE_PP0P_ clknet_4_10_0_clk
+ _00120_ VSS VSS VDD VDD net65 sky130_fd_sc_hd__dfxtp_1
Xwrapped_design.pe01.acc_out\[14\]$_SDFFE_PP0P_ clknet_4_10_0_clk
+ _00119_ VSS VSS VDD VDD net66 sky130_fd_sc_hd__dfxtp_1
Xwrapped_design.pe01.acc_out\[15\]$_SDFFE_PP0P_ clknet_4_14_0_clk
+ _00118_ VSS VSS VDD VDD net67 sky130_fd_sc_hd__dfxtp_1
Xwrapped_design.pe01.acc_out\[16\]$_SDFFE_PP0P_ clknet_4_14_0_clk
+ _00117_ VSS VSS VDD VDD net68 sky130_fd_sc_hd__dfxtp_1
Xwrapped_design.pe01.acc_out\[17\]$_SDFFE_PP0P_ clknet_4_14_0_clk
+ _00116_ VSS VSS VDD VDD net69 sky130_fd_sc_hd__dfxtp_1
Xwrapped_design.pe01.acc_out\[18\]$_SDFFE_PP0P_ clknet_4_15_0_clk
+ _00115_ VSS VSS VDD VDD net70 sky130_fd_sc_hd__dfxtp_1
Xwrapped_design.pe01.acc_out\[19\]$_SDFFE_PP0P_ clknet_4_14_0_clk
+ _00114_ VSS VSS VDD VDD net71 sky130_fd_sc_hd__dfxtp_1
Xwrapped_design.pe01.acc_out\[1\]$_SDFFE_PP0P_ clknet_4_12_0_clk
+ _00132_ VSS VSS VDD VDD net72 sky130_fd_sc_hd__dfxtp_1
Xwrapped_design.pe01.acc_out\[20\]$_SDFFE_PP0P_ clknet_4_15_0_clk
+ _00113_ VSS VSS VDD VDD net73 sky130_fd_sc_hd__dfxtp_1
Xwrapped_design.pe01.acc_out\[21\]$_SDFFE_PP0P_ clknet_4_14_0_clk
+ _00112_ VSS VSS VDD VDD net74 sky130_fd_sc_hd__dfxtp_1
Xwrapped_design.pe01.acc_out\[22\]$_SDFFE_PP0P_ clknet_4_15_0_clk
+ _00111_ VSS VSS VDD VDD net75 sky130_fd_sc_hd__dfxtp_1
Xwrapped_design.pe01.acc_out\[23\]$_SDFFE_PP0P_ clknet_4_15_0_clk
+ _00151_ VSS VSS VDD VDD net76 sky130_fd_sc_hd__dfxtp_1
Xwrapped_design.pe01.acc_out\[2\]$_SDFFE_PP0P_ clknet_4_12_0_clk
+ _00131_ VSS VSS VDD VDD net77 sky130_fd_sc_hd__dfxtp_1
Xwrapped_design.pe01.acc_out\[3\]$_SDFFE_PP0P_ clknet_4_14_0_clk
+ _00130_ VSS VSS VDD VDD net78 sky130_fd_sc_hd__dfxtp_1
Xwrapped_design.pe01.acc_out\[4\]$_SDFFE_PP0P_ clknet_4_14_0_clk
+ _00129_ VSS VSS VDD VDD net79 sky130_fd_sc_hd__dfxtp_1
Xwrapped_design.pe01.acc_out\[5\]$_SDFFE_PP0P_ clknet_4_14_0_clk
+ _00128_ VSS VSS VDD VDD net80 sky130_fd_sc_hd__dfxtp_1
Xwrapped_design.pe01.acc_out\[6\]$_SDFFE_PP0P_ clknet_4_10_0_clk
+ _00127_ VSS VSS VDD VDD net81 sky130_fd_sc_hd__dfxtp_1
Xwrapped_design.pe01.acc_out\[7\]$_SDFFE_PP0P_ clknet_4_10_0_clk
+ _00126_ VSS VSS VDD VDD net82 sky130_fd_sc_hd__dfxtp_1
Xwrapped_design.pe01.acc_out\[8\]$_SDFFE_PP0P_ clknet_4_10_0_clk
+ _00125_ VSS VSS VDD VDD net83 sky130_fd_sc_hd__dfxtp_1
Xwrapped_design.pe01.acc_out\[9\]$_SDFFE_PP0P_ clknet_4_10_0_clk
+ _00124_ VSS VSS VDD VDD net84 sky130_fd_sc_hd__dfxtp_1
Xwrapped_design.pe01.b_out\[0\]$_SDFFE_PP0P_ clknet_4_12_0_clk
+ _00110_ VSS VSS VDD VDD wrapped_design.b01_down\[0\] sky130_fd_sc_hd__dfxtp_1
Xwrapped_design.pe01.b_out\[1\]$_SDFFE_PP0P_ clknet_4_12_0_clk
+ _00109_ VSS VSS VDD VDD wrapped_design.b01_down\[1\] sky130_fd_sc_hd__dfxtp_1
Xwrapped_design.pe01.b_out\[2\]$_SDFFE_PP0P_ clknet_4_12_0_clk
+ _00108_ VSS VSS VDD VDD wrapped_design.b01_down\[2\] sky130_fd_sc_hd__dfxtp_1
Xwrapped_design.pe01.b_out\[3\]$_SDFFE_PP0P_ clknet_4_12_0_clk
+ _00107_ VSS VSS VDD VDD wrapped_design.b01_down\[3\] sky130_fd_sc_hd__dfxtp_1
Xwrapped_design.pe01.b_out\[4\]$_SDFFE_PP0P_ clknet_4_9_0_clk
+ _00106_ VSS VSS VDD VDD wrapped_design.b01_down\[4\] sky130_fd_sc_hd__dfxtp_1
Xwrapped_design.pe01.b_out\[5\]$_SDFFE_PP0P_ clknet_4_12_0_clk
+ _00105_ VSS VSS VDD VDD wrapped_design.b01_down\[5\] sky130_fd_sc_hd__dfxtp_1
Xwrapped_design.pe01.b_out\[6\]$_SDFFE_PP0P_ clknet_4_12_0_clk
+ _00104_ VSS VSS VDD VDD wrapped_design.b01_down\[6\] sky130_fd_sc_hd__dfxtp_1
Xwrapped_design.pe01.b_out\[7\]$_SDFFE_PP0P_ clknet_4_12_0_clk
+ _00150_ VSS VSS VDD VDD wrapped_design.b01_down\[7\] sky130_fd_sc_hd__dfxtp_1
Xwrapped_design.pe10.a_out\[0\]$_SDFFE_PP0P_ clknet_4_9_0_clk
+ _00043_ VSS VSS VDD VDD wrapped_design.a10_right\[0\] sky130_fd_sc_hd__dfxtp_1
Xwrapped_design.pe10.a_out\[1\]$_SDFFE_PP0P_ clknet_4_3_0_clk
+ _00042_ VSS VSS VDD VDD wrapped_design.a10_right\[1\] sky130_fd_sc_hd__dfxtp_1
Xwrapped_design.pe10.a_out\[2\]$_SDFFE_PP0P_ clknet_4_3_0_clk
+ _00041_ VSS VSS VDD VDD wrapped_design.a10_right\[2\] sky130_fd_sc_hd__dfxtp_1
Xwrapped_design.pe10.a_out\[3\]$_SDFFE_PP0P_ clknet_4_9_0_clk
+ _00040_ VSS VSS VDD VDD wrapped_design.a10_right\[3\] sky130_fd_sc_hd__dfxtp_1
Xwrapped_design.pe10.a_out\[4\]$_SDFFE_PP0P_ clknet_4_3_0_clk
+ _00039_ VSS VSS VDD VDD wrapped_design.a10_right\[4\] sky130_fd_sc_hd__dfxtp_1
Xwrapped_design.pe10.a_out\[5\]$_SDFFE_PP0P_ clknet_4_3_0_clk
+ _00038_ VSS VSS VDD VDD wrapped_design.a10_right\[5\] sky130_fd_sc_hd__dfxtp_1
Xwrapped_design.pe10.a_out\[6\]$_SDFFE_PP0P_ clknet_4_3_0_clk
+ _00037_ VSS VSS VDD VDD wrapped_design.a10_right\[6\] sky130_fd_sc_hd__dfxtp_1
Xwrapped_design.pe10.a_out\[7\]$_SDFFE_PP0P_ clknet_4_3_0_clk
+ _00142_ VSS VSS VDD VDD wrapped_design.a10_right\[7\] sky130_fd_sc_hd__dfxtp_1
Xwrapped_design.pe10.acc_out\[0\]$_SDFFE_PP0P_ clknet_4_9_0_clk
+ _00089_ VSS VSS VDD VDD net85 sky130_fd_sc_hd__dfxtp_1
Xwrapped_design.pe10.acc_out\[10\]$_SDFFE_PP0P_ clknet_4_0_0_clk
+ _00079_ VSS VSS VDD VDD net86 sky130_fd_sc_hd__dfxtp_1
Xwrapped_design.pe10.acc_out\[11\]$_SDFFE_PP0P_ clknet_4_0_0_clk
+ _00078_ VSS VSS VDD VDD net87 sky130_fd_sc_hd__dfxtp_1
Xwrapped_design.pe10.acc_out\[12\]$_SDFFE_PP0P_ clknet_4_0_0_clk
+ _00077_ VSS VSS VDD VDD net88 sky130_fd_sc_hd__dfxtp_1
Xwrapped_design.pe10.acc_out\[13\]$_SDFFE_PP0P_ clknet_4_0_0_clk
+ _00076_ VSS VSS VDD VDD net89 sky130_fd_sc_hd__dfxtp_1
Xwrapped_design.pe10.acc_out\[14\]$_SDFFE_PP0P_ clknet_4_0_0_clk
+ _00075_ VSS VSS VDD VDD net90 sky130_fd_sc_hd__dfxtp_1
Xwrapped_design.pe10.acc_out\[15\]$_SDFFE_PP0P_ clknet_4_0_0_clk
+ _00074_ VSS VSS VDD VDD net91 sky130_fd_sc_hd__dfxtp_1
Xwrapped_design.pe10.acc_out\[16\]$_SDFFE_PP0P_ clknet_4_0_0_clk
+ _00073_ VSS VSS VDD VDD net92 sky130_fd_sc_hd__dfxtp_1
Xwrapped_design.pe10.acc_out\[17\]$_SDFFE_PP0P_ clknet_4_1_0_clk
+ _00072_ VSS VSS VDD VDD net93 sky130_fd_sc_hd__dfxtp_1
Xwrapped_design.pe10.acc_out\[18\]$_SDFFE_PP0P_ clknet_4_1_0_clk
+ _00071_ VSS VSS VDD VDD net94 sky130_fd_sc_hd__dfxtp_1
Xwrapped_design.pe10.acc_out\[19\]$_SDFFE_PP0P_ clknet_4_1_0_clk
+ _00070_ VSS VSS VDD VDD net95 sky130_fd_sc_hd__dfxtp_1
Xwrapped_design.pe10.acc_out\[1\]$_SDFFE_PP0P_ clknet_4_2_0_clk
+ _00088_ VSS VSS VDD VDD net96 sky130_fd_sc_hd__dfxtp_1
Xwrapped_design.pe10.acc_out\[20\]$_SDFFE_PP0P_ clknet_4_1_0_clk
+ _00069_ VSS VSS VDD VDD net97 sky130_fd_sc_hd__dfxtp_1
Xwrapped_design.pe10.acc_out\[21\]$_SDFFE_PP0P_ clknet_4_1_0_clk
+ _00068_ VSS VSS VDD VDD net98 sky130_fd_sc_hd__dfxtp_1
Xwrapped_design.pe10.acc_out\[22\]$_SDFFE_PP0P_ clknet_4_0_0_clk
+ _00067_ VSS VSS VDD VDD net99 sky130_fd_sc_hd__dfxtp_1
Xwrapped_design.pe10.acc_out\[23\]$_SDFFE_PP0P_ clknet_4_1_0_clk
+ _00144_ VSS VSS VDD VDD net100 sky130_fd_sc_hd__dfxtp_1
Xwrapped_design.pe10.acc_out\[2\]$_SDFFE_PP0P_ clknet_4_8_0_clk
+ _00087_ VSS VSS VDD VDD net101 sky130_fd_sc_hd__dfxtp_1
Xwrapped_design.pe10.acc_out\[3\]$_SDFFE_PP0P_ clknet_4_8_0_clk
+ _00086_ VSS VSS VDD VDD net102 sky130_fd_sc_hd__dfxtp_1
Xwrapped_design.pe10.acc_out\[4\]$_SDFFE_PP0P_ clknet_4_8_0_clk
+ _00085_ VSS VSS VDD VDD net103 sky130_fd_sc_hd__dfxtp_1
Xwrapped_design.pe10.acc_out\[5\]$_SDFFE_PP0P_ clknet_4_8_0_clk
+ _00084_ VSS VSS VDD VDD net104 sky130_fd_sc_hd__dfxtp_1
Xwrapped_design.pe10.acc_out\[6\]$_SDFFE_PP0P_ clknet_4_2_0_clk
+ _00083_ VSS VSS VDD VDD net105 sky130_fd_sc_hd__dfxtp_1
Xwrapped_design.pe10.acc_out\[7\]$_SDFFE_PP0P_ clknet_4_0_0_clk
+ _00082_ VSS VSS VDD VDD net106 sky130_fd_sc_hd__dfxtp_1
Xwrapped_design.pe10.acc_out\[8\]$_SDFFE_PP0P_ clknet_4_0_0_clk
+ _00081_ VSS VSS VDD VDD net107 sky130_fd_sc_hd__dfxtp_1
Xwrapped_design.pe10.acc_out\[9\]$_SDFFE_PP0P_ clknet_4_0_0_clk
+ _00080_ VSS VSS VDD VDD net108 sky130_fd_sc_hd__dfxtp_1
Xwrapped_design.pe10.last_out$_SDFF_PP0_ clknet_4_7_0_clk
+ _00141_ VSS VSS VDD VDD wrapped_design.l10 sky130_fd_sc_hd__dfxtp_1
Xwrapped_design.pe10.start_out$_SDFF_PP0_ clknet_4_6_0_clk
+ _00140_ VSS VSS VDD VDD wrapped_design.pe10.start_out sky130_fd_sc_hd__dfxtp_1
Xwrapped_design.pe10.valid_out$_SDFF_PP0_ clknet_4_6_0_clk
+ _00139_ VSS VSS VDD VDD wrapped_design.pe10.valid_out sky130_fd_sc_hd__dfxtp_1
Xwrapped_design.pe11.acc_out\[0\]$_SDFFE_PP0P_ clknet_4_6_0_clk
+ _00022_ VSS VSS VDD VDD net109 sky130_fd_sc_hd__dfxtp_1
Xwrapped_design.pe11.acc_out\[10\]$_SDFFE_PP0P_ clknet_4_13_0_clk
+ _00012_ VSS VSS VDD VDD net110 sky130_fd_sc_hd__dfxtp_1
Xwrapped_design.pe11.acc_out\[11\]$_SDFFE_PP0P_ clknet_4_13_0_clk
+ _00011_ VSS VSS VDD VDD net111 sky130_fd_sc_hd__dfxtp_1
Xwrapped_design.pe11.acc_out\[12\]$_SDFFE_PP0P_ clknet_4_15_0_clk
+ _00010_ VSS VSS VDD VDD net112 sky130_fd_sc_hd__dfxtp_1
Xwrapped_design.pe11.acc_out\[13\]$_SDFFE_PP0P_ clknet_4_13_0_clk
+ _00009_ VSS VSS VDD VDD net113 sky130_fd_sc_hd__dfxtp_1
Xwrapped_design.pe11.acc_out\[14\]$_SDFFE_PP0P_ clknet_4_15_0_clk
+ _00008_ VSS VSS VDD VDD net114 sky130_fd_sc_hd__dfxtp_1
Xwrapped_design.pe11.acc_out\[15\]$_SDFFE_PP0P_ clknet_4_13_0_clk
+ _00007_ VSS VSS VDD VDD net115 sky130_fd_sc_hd__dfxtp_1
Xwrapped_design.pe11.acc_out\[16\]$_SDFFE_PP0P_ clknet_4_13_0_clk
+ _00006_ VSS VSS VDD VDD net116 sky130_fd_sc_hd__dfxtp_1
Xwrapped_design.pe11.acc_out\[17\]$_SDFFE_PP0P_ clknet_4_13_0_clk
+ _00005_ VSS VSS VDD VDD net117 sky130_fd_sc_hd__dfxtp_1
Xwrapped_design.pe11.acc_out\[18\]$_SDFFE_PP0P_ clknet_4_13_0_clk
+ _00004_ VSS VSS VDD VDD net118 sky130_fd_sc_hd__dfxtp_1
Xwrapped_design.pe11.acc_out\[19\]$_SDFFE_PP0P_ clknet_4_7_0_clk
+ _00003_ VSS VSS VDD VDD net119 sky130_fd_sc_hd__dfxtp_1
Xwrapped_design.pe11.acc_out\[1\]$_SDFFE_PP0P_ clknet_4_6_0_clk
+ _00021_ VSS VSS VDD VDD net120 sky130_fd_sc_hd__dfxtp_1
Xwrapped_design.pe11.acc_out\[20\]$_SDFFE_PP0P_ clknet_4_7_0_clk
+ _00002_ VSS VSS VDD VDD net121 sky130_fd_sc_hd__dfxtp_1
Xwrapped_design.pe11.acc_out\[21\]$_SDFFE_PP0P_ clknet_4_13_0_clk
+ _00001_ VSS VSS VDD VDD net122 sky130_fd_sc_hd__dfxtp_1
Xwrapped_design.pe11.acc_out\[22\]$_SDFFE_PP0P_ clknet_4_7_0_clk
+ _00000_ VSS VSS VDD VDD net123 sky130_fd_sc_hd__dfxtp_1
Xwrapped_design.pe11.acc_out\[23\]$_SDFFE_PP0P_ clknet_4_7_0_clk
+ _00136_ VSS VSS VDD VDD net124 sky130_fd_sc_hd__dfxtp_1
Xwrapped_design.pe11.acc_out\[2\]$_SDFFE_PP0P_ clknet_4_6_0_clk
+ _00020_ VSS VSS VDD VDD net125 sky130_fd_sc_hd__dfxtp_1
Xwrapped_design.pe11.acc_out\[3\]$_SDFFE_PP0P_ clknet_4_6_0_clk
+ _00019_ VSS VSS VDD VDD net126 sky130_fd_sc_hd__dfxtp_1
Xwrapped_design.pe11.acc_out\[4\]$_SDFFE_PP0P_ clknet_4_7_0_clk
+ _00018_ VSS VSS VDD VDD net127 sky130_fd_sc_hd__dfxtp_1
Xwrapped_design.pe11.acc_out\[5\]$_SDFFE_PP0P_ clknet_4_6_0_clk
+ _00017_ VSS VSS VDD VDD net128 sky130_fd_sc_hd__dfxtp_1
Xwrapped_design.pe11.acc_out\[6\]$_SDFFE_PP0P_ clknet_4_6_0_clk
+ _00016_ VSS VSS VDD VDD net129 sky130_fd_sc_hd__dfxtp_1
Xwrapped_design.pe11.acc_out\[7\]$_SDFFE_PP0P_ clknet_4_13_0_clk
+ _00015_ VSS VSS VDD VDD net130 sky130_fd_sc_hd__dfxtp_1
Xwrapped_design.pe11.acc_out\[8\]$_SDFFE_PP0P_ clknet_4_13_0_clk
+ _00014_ VSS VSS VDD VDD net131 sky130_fd_sc_hd__dfxtp_1
Xwrapped_design.pe11.acc_out\[9\]$_SDFFE_PP0P_ clknet_4_13_0_clk
+ _00013_ VSS VSS VDD VDD net132 sky130_fd_sc_hd__dfxtp_1
Xwrapped_design.pe11.last_out$_SDFF_PP0_ clknet_4_7_0_clk
+ _00135_ VSS VSS VDD VDD wrapped_design.l11 sky130_fd_sc_hd__dfxtp_1
Xwrapped_design.pe11.valid_out$_SDFF_PP0_ clknet_4_7_0_clk
+ _00134_ VSS VSS VDD VDD wrapped_design.pe11.valid_out sky130_fd_sc_hd__dfxtp_1
XTAP_TAPCELL_ROW_0_0 VSS VDD sky130_fd_sc_hd__tapvpwrvgnd_1
XTAP_TAPCELL_ROW_0_1 VSS VDD sky130_fd_sc_hd__tapvpwrvgnd_1
XTAP_TAPCELL_ROW_0_2 VSS VDD sky130_fd_sc_hd__tapvpwrvgnd_1
XTAP_TAPCELL_ROW_0_3 VSS VDD sky130_fd_sc_hd__tapvpwrvgnd_1
XTAP_TAPCELL_ROW_0_4 VSS VDD sky130_fd_sc_hd__tapvpwrvgnd_1
XTAP_TAPCELL_ROW_0_5 VSS VDD sky130_fd_sc_hd__tapvpwrvgnd_1
XTAP_TAPCELL_ROW_0_6 VSS VDD sky130_fd_sc_hd__tapvpwrvgnd_1
XTAP_TAPCELL_ROW_0_7 VSS VDD sky130_fd_sc_hd__tapvpwrvgnd_1
XTAP_TAPCELL_ROW_0_8 VSS VDD sky130_fd_sc_hd__tapvpwrvgnd_1
XTAP_TAPCELL_ROW_0_9 VSS VDD sky130_fd_sc_hd__tapvpwrvgnd_1
XTAP_TAPCELL_ROW_0_10 VSS VDD sky130_fd_sc_hd__tapvpwrvgnd_1
XTAP_TAPCELL_ROW_0_11 VSS VDD sky130_fd_sc_hd__tapvpwrvgnd_1
XTAP_TAPCELL_ROW_0_12 VSS VDD sky130_fd_sc_hd__tapvpwrvgnd_1
XTAP_TAPCELL_ROW_0_13 VSS VDD sky130_fd_sc_hd__tapvpwrvgnd_1
XTAP_TAPCELL_ROW_0_14 VSS VDD sky130_fd_sc_hd__tapvpwrvgnd_1
XTAP_TAPCELL_ROW_0_15 VSS VDD sky130_fd_sc_hd__tapvpwrvgnd_1
XTAP_TAPCELL_ROW_0_16 VSS VDD sky130_fd_sc_hd__tapvpwrvgnd_1
XTAP_TAPCELL_ROW_0_17 VSS VDD sky130_fd_sc_hd__tapvpwrvgnd_1
XTAP_TAPCELL_ROW_0_18 VSS VDD sky130_fd_sc_hd__tapvpwrvgnd_1
XTAP_TAPCELL_ROW_1_19 VSS VDD sky130_fd_sc_hd__tapvpwrvgnd_1
XTAP_TAPCELL_ROW_1_20 VSS VDD sky130_fd_sc_hd__tapvpwrvgnd_1
XTAP_TAPCELL_ROW_1_21 VSS VDD sky130_fd_sc_hd__tapvpwrvgnd_1
XTAP_TAPCELL_ROW_1_22 VSS VDD sky130_fd_sc_hd__tapvpwrvgnd_1
XTAP_TAPCELL_ROW_1_23 VSS VDD sky130_fd_sc_hd__tapvpwrvgnd_1
XTAP_TAPCELL_ROW_1_24 VSS VDD sky130_fd_sc_hd__tapvpwrvgnd_1
XTAP_TAPCELL_ROW_1_25 VSS VDD sky130_fd_sc_hd__tapvpwrvgnd_1
XTAP_TAPCELL_ROW_1_26 VSS VDD sky130_fd_sc_hd__tapvpwrvgnd_1
XTAP_TAPCELL_ROW_1_27 VSS VDD sky130_fd_sc_hd__tapvpwrvgnd_1
XTAP_TAPCELL_ROW_2_28 VSS VDD sky130_fd_sc_hd__tapvpwrvgnd_1
XTAP_TAPCELL_ROW_2_29 VSS VDD sky130_fd_sc_hd__tapvpwrvgnd_1
XTAP_TAPCELL_ROW_2_30 VSS VDD sky130_fd_sc_hd__tapvpwrvgnd_1
XTAP_TAPCELL_ROW_2_31 VSS VDD sky130_fd_sc_hd__tapvpwrvgnd_1
XTAP_TAPCELL_ROW_2_32 VSS VDD sky130_fd_sc_hd__tapvpwrvgnd_1
XTAP_TAPCELL_ROW_2_33 VSS VDD sky130_fd_sc_hd__tapvpwrvgnd_1
XTAP_TAPCELL_ROW_2_34 VSS VDD sky130_fd_sc_hd__tapvpwrvgnd_1
XTAP_TAPCELL_ROW_2_35 VSS VDD sky130_fd_sc_hd__tapvpwrvgnd_1
XTAP_TAPCELL_ROW_2_36 VSS VDD sky130_fd_sc_hd__tapvpwrvgnd_1
XTAP_TAPCELL_ROW_2_37 VSS VDD sky130_fd_sc_hd__tapvpwrvgnd_1
XTAP_TAPCELL_ROW_3_38 VSS VDD sky130_fd_sc_hd__tapvpwrvgnd_1
XTAP_TAPCELL_ROW_3_39 VSS VDD sky130_fd_sc_hd__tapvpwrvgnd_1
XTAP_TAPCELL_ROW_3_40 VSS VDD sky130_fd_sc_hd__tapvpwrvgnd_1
XTAP_TAPCELL_ROW_3_41 VSS VDD sky130_fd_sc_hd__tapvpwrvgnd_1
XTAP_TAPCELL_ROW_3_42 VSS VDD sky130_fd_sc_hd__tapvpwrvgnd_1
XTAP_TAPCELL_ROW_3_43 VSS VDD sky130_fd_sc_hd__tapvpwrvgnd_1
XTAP_TAPCELL_ROW_3_44 VSS VDD sky130_fd_sc_hd__tapvpwrvgnd_1
XTAP_TAPCELL_ROW_3_45 VSS VDD sky130_fd_sc_hd__tapvpwrvgnd_1
XTAP_TAPCELL_ROW_3_46 VSS VDD sky130_fd_sc_hd__tapvpwrvgnd_1
XTAP_TAPCELL_ROW_4_47 VSS VDD sky130_fd_sc_hd__tapvpwrvgnd_1
XTAP_TAPCELL_ROW_4_48 VSS VDD sky130_fd_sc_hd__tapvpwrvgnd_1
XTAP_TAPCELL_ROW_4_49 VSS VDD sky130_fd_sc_hd__tapvpwrvgnd_1
XTAP_TAPCELL_ROW_4_50 VSS VDD sky130_fd_sc_hd__tapvpwrvgnd_1
XTAP_TAPCELL_ROW_4_51 VSS VDD sky130_fd_sc_hd__tapvpwrvgnd_1
XTAP_TAPCELL_ROW_4_52 VSS VDD sky130_fd_sc_hd__tapvpwrvgnd_1
XTAP_TAPCELL_ROW_4_53 VSS VDD sky130_fd_sc_hd__tapvpwrvgnd_1
XTAP_TAPCELL_ROW_4_54 VSS VDD sky130_fd_sc_hd__tapvpwrvgnd_1
XTAP_TAPCELL_ROW_4_55 VSS VDD sky130_fd_sc_hd__tapvpwrvgnd_1
XTAP_TAPCELL_ROW_4_56 VSS VDD sky130_fd_sc_hd__tapvpwrvgnd_1
XTAP_TAPCELL_ROW_5_57 VSS VDD sky130_fd_sc_hd__tapvpwrvgnd_1
XTAP_TAPCELL_ROW_5_58 VSS VDD sky130_fd_sc_hd__tapvpwrvgnd_1
XTAP_TAPCELL_ROW_5_59 VSS VDD sky130_fd_sc_hd__tapvpwrvgnd_1
XTAP_TAPCELL_ROW_5_60 VSS VDD sky130_fd_sc_hd__tapvpwrvgnd_1
XTAP_TAPCELL_ROW_5_61 VSS VDD sky130_fd_sc_hd__tapvpwrvgnd_1
XTAP_TAPCELL_ROW_5_62 VSS VDD sky130_fd_sc_hd__tapvpwrvgnd_1
XTAP_TAPCELL_ROW_5_63 VSS VDD sky130_fd_sc_hd__tapvpwrvgnd_1
XTAP_TAPCELL_ROW_5_64 VSS VDD sky130_fd_sc_hd__tapvpwrvgnd_1
XTAP_TAPCELL_ROW_5_65 VSS VDD sky130_fd_sc_hd__tapvpwrvgnd_1
XTAP_TAPCELL_ROW_6_66 VSS VDD sky130_fd_sc_hd__tapvpwrvgnd_1
XTAP_TAPCELL_ROW_6_67 VSS VDD sky130_fd_sc_hd__tapvpwrvgnd_1
XTAP_TAPCELL_ROW_6_68 VSS VDD sky130_fd_sc_hd__tapvpwrvgnd_1
XTAP_TAPCELL_ROW_6_69 VSS VDD sky130_fd_sc_hd__tapvpwrvgnd_1
XTAP_TAPCELL_ROW_6_70 VSS VDD sky130_fd_sc_hd__tapvpwrvgnd_1
XTAP_TAPCELL_ROW_6_71 VSS VDD sky130_fd_sc_hd__tapvpwrvgnd_1
XTAP_TAPCELL_ROW_6_72 VSS VDD sky130_fd_sc_hd__tapvpwrvgnd_1
XTAP_TAPCELL_ROW_6_73 VSS VDD sky130_fd_sc_hd__tapvpwrvgnd_1
XTAP_TAPCELL_ROW_6_74 VSS VDD sky130_fd_sc_hd__tapvpwrvgnd_1
XTAP_TAPCELL_ROW_6_75 VSS VDD sky130_fd_sc_hd__tapvpwrvgnd_1
XTAP_TAPCELL_ROW_7_76 VSS VDD sky130_fd_sc_hd__tapvpwrvgnd_1
XTAP_TAPCELL_ROW_7_77 VSS VDD sky130_fd_sc_hd__tapvpwrvgnd_1
XTAP_TAPCELL_ROW_7_78 VSS VDD sky130_fd_sc_hd__tapvpwrvgnd_1
XTAP_TAPCELL_ROW_7_79 VSS VDD sky130_fd_sc_hd__tapvpwrvgnd_1
XTAP_TAPCELL_ROW_7_80 VSS VDD sky130_fd_sc_hd__tapvpwrvgnd_1
XTAP_TAPCELL_ROW_7_81 VSS VDD sky130_fd_sc_hd__tapvpwrvgnd_1
XTAP_TAPCELL_ROW_7_82 VSS VDD sky130_fd_sc_hd__tapvpwrvgnd_1
XTAP_TAPCELL_ROW_7_83 VSS VDD sky130_fd_sc_hd__tapvpwrvgnd_1
XTAP_TAPCELL_ROW_7_84 VSS VDD sky130_fd_sc_hd__tapvpwrvgnd_1
XTAP_TAPCELL_ROW_8_85 VSS VDD sky130_fd_sc_hd__tapvpwrvgnd_1
XTAP_TAPCELL_ROW_8_86 VSS VDD sky130_fd_sc_hd__tapvpwrvgnd_1
XTAP_TAPCELL_ROW_8_87 VSS VDD sky130_fd_sc_hd__tapvpwrvgnd_1
XTAP_TAPCELL_ROW_8_88 VSS VDD sky130_fd_sc_hd__tapvpwrvgnd_1
XTAP_TAPCELL_ROW_8_89 VSS VDD sky130_fd_sc_hd__tapvpwrvgnd_1
XTAP_TAPCELL_ROW_8_90 VSS VDD sky130_fd_sc_hd__tapvpwrvgnd_1
XTAP_TAPCELL_ROW_8_91 VSS VDD sky130_fd_sc_hd__tapvpwrvgnd_1
XTAP_TAPCELL_ROW_8_92 VSS VDD sky130_fd_sc_hd__tapvpwrvgnd_1
XTAP_TAPCELL_ROW_8_93 VSS VDD sky130_fd_sc_hd__tapvpwrvgnd_1
XTAP_TAPCELL_ROW_8_94 VSS VDD sky130_fd_sc_hd__tapvpwrvgnd_1
XTAP_TAPCELL_ROW_9_95 VSS VDD sky130_fd_sc_hd__tapvpwrvgnd_1
XTAP_TAPCELL_ROW_9_96 VSS VDD sky130_fd_sc_hd__tapvpwrvgnd_1
XTAP_TAPCELL_ROW_9_97 VSS VDD sky130_fd_sc_hd__tapvpwrvgnd_1
XTAP_TAPCELL_ROW_9_98 VSS VDD sky130_fd_sc_hd__tapvpwrvgnd_1
XTAP_TAPCELL_ROW_9_99 VSS VDD sky130_fd_sc_hd__tapvpwrvgnd_1
XTAP_TAPCELL_ROW_9_100 VSS VDD sky130_fd_sc_hd__tapvpwrvgnd_1
XTAP_TAPCELL_ROW_9_101 VSS VDD sky130_fd_sc_hd__tapvpwrvgnd_1
XTAP_TAPCELL_ROW_9_102 VSS VDD sky130_fd_sc_hd__tapvpwrvgnd_1
XTAP_TAPCELL_ROW_9_103 VSS VDD sky130_fd_sc_hd__tapvpwrvgnd_1
XTAP_TAPCELL_ROW_10_104 VSS VDD sky130_fd_sc_hd__tapvpwrvgnd_1
XTAP_TAPCELL_ROW_10_105 VSS VDD sky130_fd_sc_hd__tapvpwrvgnd_1
XTAP_TAPCELL_ROW_10_106 VSS VDD sky130_fd_sc_hd__tapvpwrvgnd_1
XTAP_TAPCELL_ROW_10_107 VSS VDD sky130_fd_sc_hd__tapvpwrvgnd_1
XTAP_TAPCELL_ROW_10_108 VSS VDD sky130_fd_sc_hd__tapvpwrvgnd_1
XTAP_TAPCELL_ROW_10_109 VSS VDD sky130_fd_sc_hd__tapvpwrvgnd_1
XTAP_TAPCELL_ROW_10_110 VSS VDD sky130_fd_sc_hd__tapvpwrvgnd_1
XTAP_TAPCELL_ROW_10_111 VSS VDD sky130_fd_sc_hd__tapvpwrvgnd_1
XTAP_TAPCELL_ROW_10_112 VSS VDD sky130_fd_sc_hd__tapvpwrvgnd_1
XTAP_TAPCELL_ROW_10_113 VSS VDD sky130_fd_sc_hd__tapvpwrvgnd_1
XTAP_TAPCELL_ROW_11_114 VSS VDD sky130_fd_sc_hd__tapvpwrvgnd_1
XTAP_TAPCELL_ROW_11_115 VSS VDD sky130_fd_sc_hd__tapvpwrvgnd_1
XTAP_TAPCELL_ROW_11_116 VSS VDD sky130_fd_sc_hd__tapvpwrvgnd_1
XTAP_TAPCELL_ROW_11_117 VSS VDD sky130_fd_sc_hd__tapvpwrvgnd_1
XTAP_TAPCELL_ROW_11_118 VSS VDD sky130_fd_sc_hd__tapvpwrvgnd_1
XTAP_TAPCELL_ROW_11_119 VSS VDD sky130_fd_sc_hd__tapvpwrvgnd_1
XTAP_TAPCELL_ROW_11_120 VSS VDD sky130_fd_sc_hd__tapvpwrvgnd_1
XTAP_TAPCELL_ROW_11_121 VSS VDD sky130_fd_sc_hd__tapvpwrvgnd_1
XTAP_TAPCELL_ROW_11_122 VSS VDD sky130_fd_sc_hd__tapvpwrvgnd_1
XTAP_TAPCELL_ROW_12_123 VSS VDD sky130_fd_sc_hd__tapvpwrvgnd_1
XTAP_TAPCELL_ROW_12_124 VSS VDD sky130_fd_sc_hd__tapvpwrvgnd_1
XTAP_TAPCELL_ROW_12_125 VSS VDD sky130_fd_sc_hd__tapvpwrvgnd_1
XTAP_TAPCELL_ROW_12_126 VSS VDD sky130_fd_sc_hd__tapvpwrvgnd_1
XTAP_TAPCELL_ROW_12_127 VSS VDD sky130_fd_sc_hd__tapvpwrvgnd_1
XTAP_TAPCELL_ROW_12_128 VSS VDD sky130_fd_sc_hd__tapvpwrvgnd_1
XTAP_TAPCELL_ROW_12_129 VSS VDD sky130_fd_sc_hd__tapvpwrvgnd_1
XTAP_TAPCELL_ROW_12_130 VSS VDD sky130_fd_sc_hd__tapvpwrvgnd_1
XTAP_TAPCELL_ROW_12_131 VSS VDD sky130_fd_sc_hd__tapvpwrvgnd_1
XTAP_TAPCELL_ROW_12_132 VSS VDD sky130_fd_sc_hd__tapvpwrvgnd_1
XTAP_TAPCELL_ROW_13_133 VSS VDD sky130_fd_sc_hd__tapvpwrvgnd_1
XTAP_TAPCELL_ROW_13_134 VSS VDD sky130_fd_sc_hd__tapvpwrvgnd_1
XTAP_TAPCELL_ROW_13_135 VSS VDD sky130_fd_sc_hd__tapvpwrvgnd_1
XTAP_TAPCELL_ROW_13_136 VSS VDD sky130_fd_sc_hd__tapvpwrvgnd_1
XTAP_TAPCELL_ROW_13_137 VSS VDD sky130_fd_sc_hd__tapvpwrvgnd_1
XTAP_TAPCELL_ROW_13_138 VSS VDD sky130_fd_sc_hd__tapvpwrvgnd_1
XTAP_TAPCELL_ROW_13_139 VSS VDD sky130_fd_sc_hd__tapvpwrvgnd_1
XTAP_TAPCELL_ROW_13_140 VSS VDD sky130_fd_sc_hd__tapvpwrvgnd_1
XTAP_TAPCELL_ROW_13_141 VSS VDD sky130_fd_sc_hd__tapvpwrvgnd_1
XTAP_TAPCELL_ROW_14_142 VSS VDD sky130_fd_sc_hd__tapvpwrvgnd_1
XTAP_TAPCELL_ROW_14_143 VSS VDD sky130_fd_sc_hd__tapvpwrvgnd_1
XTAP_TAPCELL_ROW_14_144 VSS VDD sky130_fd_sc_hd__tapvpwrvgnd_1
XTAP_TAPCELL_ROW_14_145 VSS VDD sky130_fd_sc_hd__tapvpwrvgnd_1
XTAP_TAPCELL_ROW_14_146 VSS VDD sky130_fd_sc_hd__tapvpwrvgnd_1
XTAP_TAPCELL_ROW_14_147 VSS VDD sky130_fd_sc_hd__tapvpwrvgnd_1
XTAP_TAPCELL_ROW_14_148 VSS VDD sky130_fd_sc_hd__tapvpwrvgnd_1
XTAP_TAPCELL_ROW_14_149 VSS VDD sky130_fd_sc_hd__tapvpwrvgnd_1
XTAP_TAPCELL_ROW_14_150 VSS VDD sky130_fd_sc_hd__tapvpwrvgnd_1
XTAP_TAPCELL_ROW_14_151 VSS VDD sky130_fd_sc_hd__tapvpwrvgnd_1
XTAP_TAPCELL_ROW_15_152 VSS VDD sky130_fd_sc_hd__tapvpwrvgnd_1
XTAP_TAPCELL_ROW_15_153 VSS VDD sky130_fd_sc_hd__tapvpwrvgnd_1
XTAP_TAPCELL_ROW_15_154 VSS VDD sky130_fd_sc_hd__tapvpwrvgnd_1
XTAP_TAPCELL_ROW_15_155 VSS VDD sky130_fd_sc_hd__tapvpwrvgnd_1
XTAP_TAPCELL_ROW_15_156 VSS VDD sky130_fd_sc_hd__tapvpwrvgnd_1
XTAP_TAPCELL_ROW_15_157 VSS VDD sky130_fd_sc_hd__tapvpwrvgnd_1
XTAP_TAPCELL_ROW_15_158 VSS VDD sky130_fd_sc_hd__tapvpwrvgnd_1
XTAP_TAPCELL_ROW_15_159 VSS VDD sky130_fd_sc_hd__tapvpwrvgnd_1
XTAP_TAPCELL_ROW_15_160 VSS VDD sky130_fd_sc_hd__tapvpwrvgnd_1
XTAP_TAPCELL_ROW_16_161 VSS VDD sky130_fd_sc_hd__tapvpwrvgnd_1
XTAP_TAPCELL_ROW_16_162 VSS VDD sky130_fd_sc_hd__tapvpwrvgnd_1
XTAP_TAPCELL_ROW_16_163 VSS VDD sky130_fd_sc_hd__tapvpwrvgnd_1
XTAP_TAPCELL_ROW_16_164 VSS VDD sky130_fd_sc_hd__tapvpwrvgnd_1
XTAP_TAPCELL_ROW_16_165 VSS VDD sky130_fd_sc_hd__tapvpwrvgnd_1
XTAP_TAPCELL_ROW_16_166 VSS VDD sky130_fd_sc_hd__tapvpwrvgnd_1
XTAP_TAPCELL_ROW_16_167 VSS VDD sky130_fd_sc_hd__tapvpwrvgnd_1
XTAP_TAPCELL_ROW_16_168 VSS VDD sky130_fd_sc_hd__tapvpwrvgnd_1
XTAP_TAPCELL_ROW_16_169 VSS VDD sky130_fd_sc_hd__tapvpwrvgnd_1
XTAP_TAPCELL_ROW_16_170 VSS VDD sky130_fd_sc_hd__tapvpwrvgnd_1
XTAP_TAPCELL_ROW_17_171 VSS VDD sky130_fd_sc_hd__tapvpwrvgnd_1
XTAP_TAPCELL_ROW_17_172 VSS VDD sky130_fd_sc_hd__tapvpwrvgnd_1
XTAP_TAPCELL_ROW_17_173 VSS VDD sky130_fd_sc_hd__tapvpwrvgnd_1
XTAP_TAPCELL_ROW_17_174 VSS VDD sky130_fd_sc_hd__tapvpwrvgnd_1
XTAP_TAPCELL_ROW_17_175 VSS VDD sky130_fd_sc_hd__tapvpwrvgnd_1
XTAP_TAPCELL_ROW_17_176 VSS VDD sky130_fd_sc_hd__tapvpwrvgnd_1
XTAP_TAPCELL_ROW_17_177 VSS VDD sky130_fd_sc_hd__tapvpwrvgnd_1
XTAP_TAPCELL_ROW_17_178 VSS VDD sky130_fd_sc_hd__tapvpwrvgnd_1
XTAP_TAPCELL_ROW_17_179 VSS VDD sky130_fd_sc_hd__tapvpwrvgnd_1
XTAP_TAPCELL_ROW_18_180 VSS VDD sky130_fd_sc_hd__tapvpwrvgnd_1
XTAP_TAPCELL_ROW_18_181 VSS VDD sky130_fd_sc_hd__tapvpwrvgnd_1
XTAP_TAPCELL_ROW_18_182 VSS VDD sky130_fd_sc_hd__tapvpwrvgnd_1
XTAP_TAPCELL_ROW_18_183 VSS VDD sky130_fd_sc_hd__tapvpwrvgnd_1
XTAP_TAPCELL_ROW_18_184 VSS VDD sky130_fd_sc_hd__tapvpwrvgnd_1
XTAP_TAPCELL_ROW_18_185 VSS VDD sky130_fd_sc_hd__tapvpwrvgnd_1
XTAP_TAPCELL_ROW_18_186 VSS VDD sky130_fd_sc_hd__tapvpwrvgnd_1
XTAP_TAPCELL_ROW_18_187 VSS VDD sky130_fd_sc_hd__tapvpwrvgnd_1
XTAP_TAPCELL_ROW_18_188 VSS VDD sky130_fd_sc_hd__tapvpwrvgnd_1
XTAP_TAPCELL_ROW_18_189 VSS VDD sky130_fd_sc_hd__tapvpwrvgnd_1
XTAP_TAPCELL_ROW_19_190 VSS VDD sky130_fd_sc_hd__tapvpwrvgnd_1
XTAP_TAPCELL_ROW_19_191 VSS VDD sky130_fd_sc_hd__tapvpwrvgnd_1
XTAP_TAPCELL_ROW_19_192 VSS VDD sky130_fd_sc_hd__tapvpwrvgnd_1
XTAP_TAPCELL_ROW_19_193 VSS VDD sky130_fd_sc_hd__tapvpwrvgnd_1
XTAP_TAPCELL_ROW_19_194 VSS VDD sky130_fd_sc_hd__tapvpwrvgnd_1
XTAP_TAPCELL_ROW_19_195 VSS VDD sky130_fd_sc_hd__tapvpwrvgnd_1
XTAP_TAPCELL_ROW_19_196 VSS VDD sky130_fd_sc_hd__tapvpwrvgnd_1
XTAP_TAPCELL_ROW_19_197 VSS VDD sky130_fd_sc_hd__tapvpwrvgnd_1
XTAP_TAPCELL_ROW_19_198 VSS VDD sky130_fd_sc_hd__tapvpwrvgnd_1
XTAP_TAPCELL_ROW_20_199 VSS VDD sky130_fd_sc_hd__tapvpwrvgnd_1
XTAP_TAPCELL_ROW_20_200 VSS VDD sky130_fd_sc_hd__tapvpwrvgnd_1
XTAP_TAPCELL_ROW_20_201 VSS VDD sky130_fd_sc_hd__tapvpwrvgnd_1
XTAP_TAPCELL_ROW_20_202 VSS VDD sky130_fd_sc_hd__tapvpwrvgnd_1
XTAP_TAPCELL_ROW_20_203 VSS VDD sky130_fd_sc_hd__tapvpwrvgnd_1
XTAP_TAPCELL_ROW_20_204 VSS VDD sky130_fd_sc_hd__tapvpwrvgnd_1
XTAP_TAPCELL_ROW_20_205 VSS VDD sky130_fd_sc_hd__tapvpwrvgnd_1
XTAP_TAPCELL_ROW_20_206 VSS VDD sky130_fd_sc_hd__tapvpwrvgnd_1
XTAP_TAPCELL_ROW_20_207 VSS VDD sky130_fd_sc_hd__tapvpwrvgnd_1
XTAP_TAPCELL_ROW_20_208 VSS VDD sky130_fd_sc_hd__tapvpwrvgnd_1
XTAP_TAPCELL_ROW_21_209 VSS VDD sky130_fd_sc_hd__tapvpwrvgnd_1
XTAP_TAPCELL_ROW_21_210 VSS VDD sky130_fd_sc_hd__tapvpwrvgnd_1
XTAP_TAPCELL_ROW_21_211 VSS VDD sky130_fd_sc_hd__tapvpwrvgnd_1
XTAP_TAPCELL_ROW_21_212 VSS VDD sky130_fd_sc_hd__tapvpwrvgnd_1
XTAP_TAPCELL_ROW_21_213 VSS VDD sky130_fd_sc_hd__tapvpwrvgnd_1
XTAP_TAPCELL_ROW_21_214 VSS VDD sky130_fd_sc_hd__tapvpwrvgnd_1
XTAP_TAPCELL_ROW_21_215 VSS VDD sky130_fd_sc_hd__tapvpwrvgnd_1
XTAP_TAPCELL_ROW_21_216 VSS VDD sky130_fd_sc_hd__tapvpwrvgnd_1
XTAP_TAPCELL_ROW_21_217 VSS VDD sky130_fd_sc_hd__tapvpwrvgnd_1
XTAP_TAPCELL_ROW_22_218 VSS VDD sky130_fd_sc_hd__tapvpwrvgnd_1
XTAP_TAPCELL_ROW_22_219 VSS VDD sky130_fd_sc_hd__tapvpwrvgnd_1
XTAP_TAPCELL_ROW_22_220 VSS VDD sky130_fd_sc_hd__tapvpwrvgnd_1
XTAP_TAPCELL_ROW_22_221 VSS VDD sky130_fd_sc_hd__tapvpwrvgnd_1
XTAP_TAPCELL_ROW_22_222 VSS VDD sky130_fd_sc_hd__tapvpwrvgnd_1
XTAP_TAPCELL_ROW_22_223 VSS VDD sky130_fd_sc_hd__tapvpwrvgnd_1
XTAP_TAPCELL_ROW_22_224 VSS VDD sky130_fd_sc_hd__tapvpwrvgnd_1
XTAP_TAPCELL_ROW_22_225 VSS VDD sky130_fd_sc_hd__tapvpwrvgnd_1
XTAP_TAPCELL_ROW_22_226 VSS VDD sky130_fd_sc_hd__tapvpwrvgnd_1
XTAP_TAPCELL_ROW_22_227 VSS VDD sky130_fd_sc_hd__tapvpwrvgnd_1
XTAP_TAPCELL_ROW_23_228 VSS VDD sky130_fd_sc_hd__tapvpwrvgnd_1
XTAP_TAPCELL_ROW_23_229 VSS VDD sky130_fd_sc_hd__tapvpwrvgnd_1
XTAP_TAPCELL_ROW_23_230 VSS VDD sky130_fd_sc_hd__tapvpwrvgnd_1
XTAP_TAPCELL_ROW_23_231 VSS VDD sky130_fd_sc_hd__tapvpwrvgnd_1
XTAP_TAPCELL_ROW_23_232 VSS VDD sky130_fd_sc_hd__tapvpwrvgnd_1
XTAP_TAPCELL_ROW_23_233 VSS VDD sky130_fd_sc_hd__tapvpwrvgnd_1
XTAP_TAPCELL_ROW_23_234 VSS VDD sky130_fd_sc_hd__tapvpwrvgnd_1
XTAP_TAPCELL_ROW_23_235 VSS VDD sky130_fd_sc_hd__tapvpwrvgnd_1
XTAP_TAPCELL_ROW_23_236 VSS VDD sky130_fd_sc_hd__tapvpwrvgnd_1
XTAP_TAPCELL_ROW_24_237 VSS VDD sky130_fd_sc_hd__tapvpwrvgnd_1
XTAP_TAPCELL_ROW_24_238 VSS VDD sky130_fd_sc_hd__tapvpwrvgnd_1
XTAP_TAPCELL_ROW_24_239 VSS VDD sky130_fd_sc_hd__tapvpwrvgnd_1
XTAP_TAPCELL_ROW_24_240 VSS VDD sky130_fd_sc_hd__tapvpwrvgnd_1
XTAP_TAPCELL_ROW_24_241 VSS VDD sky130_fd_sc_hd__tapvpwrvgnd_1
XTAP_TAPCELL_ROW_24_242 VSS VDD sky130_fd_sc_hd__tapvpwrvgnd_1
XTAP_TAPCELL_ROW_24_243 VSS VDD sky130_fd_sc_hd__tapvpwrvgnd_1
XTAP_TAPCELL_ROW_24_244 VSS VDD sky130_fd_sc_hd__tapvpwrvgnd_1
XTAP_TAPCELL_ROW_24_245 VSS VDD sky130_fd_sc_hd__tapvpwrvgnd_1
XTAP_TAPCELL_ROW_24_246 VSS VDD sky130_fd_sc_hd__tapvpwrvgnd_1
XTAP_TAPCELL_ROW_25_247 VSS VDD sky130_fd_sc_hd__tapvpwrvgnd_1
XTAP_TAPCELL_ROW_25_248 VSS VDD sky130_fd_sc_hd__tapvpwrvgnd_1
XTAP_TAPCELL_ROW_25_249 VSS VDD sky130_fd_sc_hd__tapvpwrvgnd_1
XTAP_TAPCELL_ROW_25_250 VSS VDD sky130_fd_sc_hd__tapvpwrvgnd_1
XTAP_TAPCELL_ROW_25_251 VSS VDD sky130_fd_sc_hd__tapvpwrvgnd_1
XTAP_TAPCELL_ROW_25_252 VSS VDD sky130_fd_sc_hd__tapvpwrvgnd_1
XTAP_TAPCELL_ROW_25_253 VSS VDD sky130_fd_sc_hd__tapvpwrvgnd_1
XTAP_TAPCELL_ROW_25_254 VSS VDD sky130_fd_sc_hd__tapvpwrvgnd_1
XTAP_TAPCELL_ROW_25_255 VSS VDD sky130_fd_sc_hd__tapvpwrvgnd_1
XTAP_TAPCELL_ROW_26_256 VSS VDD sky130_fd_sc_hd__tapvpwrvgnd_1
XTAP_TAPCELL_ROW_26_257 VSS VDD sky130_fd_sc_hd__tapvpwrvgnd_1
XTAP_TAPCELL_ROW_26_258 VSS VDD sky130_fd_sc_hd__tapvpwrvgnd_1
XTAP_TAPCELL_ROW_26_259 VSS VDD sky130_fd_sc_hd__tapvpwrvgnd_1
XTAP_TAPCELL_ROW_26_260 VSS VDD sky130_fd_sc_hd__tapvpwrvgnd_1
XTAP_TAPCELL_ROW_26_261 VSS VDD sky130_fd_sc_hd__tapvpwrvgnd_1
XTAP_TAPCELL_ROW_26_262 VSS VDD sky130_fd_sc_hd__tapvpwrvgnd_1
XTAP_TAPCELL_ROW_26_263 VSS VDD sky130_fd_sc_hd__tapvpwrvgnd_1
XTAP_TAPCELL_ROW_26_264 VSS VDD sky130_fd_sc_hd__tapvpwrvgnd_1
XTAP_TAPCELL_ROW_26_265 VSS VDD sky130_fd_sc_hd__tapvpwrvgnd_1
XTAP_TAPCELL_ROW_27_266 VSS VDD sky130_fd_sc_hd__tapvpwrvgnd_1
XTAP_TAPCELL_ROW_27_267 VSS VDD sky130_fd_sc_hd__tapvpwrvgnd_1
XTAP_TAPCELL_ROW_27_268 VSS VDD sky130_fd_sc_hd__tapvpwrvgnd_1
XTAP_TAPCELL_ROW_27_269 VSS VDD sky130_fd_sc_hd__tapvpwrvgnd_1
XTAP_TAPCELL_ROW_27_270 VSS VDD sky130_fd_sc_hd__tapvpwrvgnd_1
XTAP_TAPCELL_ROW_27_271 VSS VDD sky130_fd_sc_hd__tapvpwrvgnd_1
XTAP_TAPCELL_ROW_27_272 VSS VDD sky130_fd_sc_hd__tapvpwrvgnd_1
XTAP_TAPCELL_ROW_27_273 VSS VDD sky130_fd_sc_hd__tapvpwrvgnd_1
XTAP_TAPCELL_ROW_27_274 VSS VDD sky130_fd_sc_hd__tapvpwrvgnd_1
XTAP_TAPCELL_ROW_28_275 VSS VDD sky130_fd_sc_hd__tapvpwrvgnd_1
XTAP_TAPCELL_ROW_28_276 VSS VDD sky130_fd_sc_hd__tapvpwrvgnd_1
XTAP_TAPCELL_ROW_28_277 VSS VDD sky130_fd_sc_hd__tapvpwrvgnd_1
XTAP_TAPCELL_ROW_28_278 VSS VDD sky130_fd_sc_hd__tapvpwrvgnd_1
XTAP_TAPCELL_ROW_28_279 VSS VDD sky130_fd_sc_hd__tapvpwrvgnd_1
XTAP_TAPCELL_ROW_28_280 VSS VDD sky130_fd_sc_hd__tapvpwrvgnd_1
XTAP_TAPCELL_ROW_28_281 VSS VDD sky130_fd_sc_hd__tapvpwrvgnd_1
XTAP_TAPCELL_ROW_28_282 VSS VDD sky130_fd_sc_hd__tapvpwrvgnd_1
XTAP_TAPCELL_ROW_28_283 VSS VDD sky130_fd_sc_hd__tapvpwrvgnd_1
XTAP_TAPCELL_ROW_28_284 VSS VDD sky130_fd_sc_hd__tapvpwrvgnd_1
XTAP_TAPCELL_ROW_29_285 VSS VDD sky130_fd_sc_hd__tapvpwrvgnd_1
XTAP_TAPCELL_ROW_29_286 VSS VDD sky130_fd_sc_hd__tapvpwrvgnd_1
XTAP_TAPCELL_ROW_29_287 VSS VDD sky130_fd_sc_hd__tapvpwrvgnd_1
XTAP_TAPCELL_ROW_29_288 VSS VDD sky130_fd_sc_hd__tapvpwrvgnd_1
XTAP_TAPCELL_ROW_29_289 VSS VDD sky130_fd_sc_hd__tapvpwrvgnd_1
XTAP_TAPCELL_ROW_29_290 VSS VDD sky130_fd_sc_hd__tapvpwrvgnd_1
XTAP_TAPCELL_ROW_29_291 VSS VDD sky130_fd_sc_hd__tapvpwrvgnd_1
XTAP_TAPCELL_ROW_29_292 VSS VDD sky130_fd_sc_hd__tapvpwrvgnd_1
XTAP_TAPCELL_ROW_29_293 VSS VDD sky130_fd_sc_hd__tapvpwrvgnd_1
XTAP_TAPCELL_ROW_30_294 VSS VDD sky130_fd_sc_hd__tapvpwrvgnd_1
XTAP_TAPCELL_ROW_30_295 VSS VDD sky130_fd_sc_hd__tapvpwrvgnd_1
XTAP_TAPCELL_ROW_30_296 VSS VDD sky130_fd_sc_hd__tapvpwrvgnd_1
XTAP_TAPCELL_ROW_30_297 VSS VDD sky130_fd_sc_hd__tapvpwrvgnd_1
XTAP_TAPCELL_ROW_30_298 VSS VDD sky130_fd_sc_hd__tapvpwrvgnd_1
XTAP_TAPCELL_ROW_30_299 VSS VDD sky130_fd_sc_hd__tapvpwrvgnd_1
XTAP_TAPCELL_ROW_30_300 VSS VDD sky130_fd_sc_hd__tapvpwrvgnd_1
XTAP_TAPCELL_ROW_30_301 VSS VDD sky130_fd_sc_hd__tapvpwrvgnd_1
XTAP_TAPCELL_ROW_30_302 VSS VDD sky130_fd_sc_hd__tapvpwrvgnd_1
XTAP_TAPCELL_ROW_30_303 VSS VDD sky130_fd_sc_hd__tapvpwrvgnd_1
XTAP_TAPCELL_ROW_31_304 VSS VDD sky130_fd_sc_hd__tapvpwrvgnd_1
XTAP_TAPCELL_ROW_31_305 VSS VDD sky130_fd_sc_hd__tapvpwrvgnd_1
XTAP_TAPCELL_ROW_31_306 VSS VDD sky130_fd_sc_hd__tapvpwrvgnd_1
XTAP_TAPCELL_ROW_31_307 VSS VDD sky130_fd_sc_hd__tapvpwrvgnd_1
XTAP_TAPCELL_ROW_31_308 VSS VDD sky130_fd_sc_hd__tapvpwrvgnd_1
XTAP_TAPCELL_ROW_31_309 VSS VDD sky130_fd_sc_hd__tapvpwrvgnd_1
XTAP_TAPCELL_ROW_31_310 VSS VDD sky130_fd_sc_hd__tapvpwrvgnd_1
XTAP_TAPCELL_ROW_31_311 VSS VDD sky130_fd_sc_hd__tapvpwrvgnd_1
XTAP_TAPCELL_ROW_31_312 VSS VDD sky130_fd_sc_hd__tapvpwrvgnd_1
XTAP_TAPCELL_ROW_32_313 VSS VDD sky130_fd_sc_hd__tapvpwrvgnd_1
XTAP_TAPCELL_ROW_32_314 VSS VDD sky130_fd_sc_hd__tapvpwrvgnd_1
XTAP_TAPCELL_ROW_32_315 VSS VDD sky130_fd_sc_hd__tapvpwrvgnd_1
XTAP_TAPCELL_ROW_32_316 VSS VDD sky130_fd_sc_hd__tapvpwrvgnd_1
XTAP_TAPCELL_ROW_32_317 VSS VDD sky130_fd_sc_hd__tapvpwrvgnd_1
XTAP_TAPCELL_ROW_32_318 VSS VDD sky130_fd_sc_hd__tapvpwrvgnd_1
XTAP_TAPCELL_ROW_32_319 VSS VDD sky130_fd_sc_hd__tapvpwrvgnd_1
XTAP_TAPCELL_ROW_32_320 VSS VDD sky130_fd_sc_hd__tapvpwrvgnd_1
XTAP_TAPCELL_ROW_32_321 VSS VDD sky130_fd_sc_hd__tapvpwrvgnd_1
XTAP_TAPCELL_ROW_32_322 VSS VDD sky130_fd_sc_hd__tapvpwrvgnd_1
XTAP_TAPCELL_ROW_33_323 VSS VDD sky130_fd_sc_hd__tapvpwrvgnd_1
XTAP_TAPCELL_ROW_33_324 VSS VDD sky130_fd_sc_hd__tapvpwrvgnd_1
XTAP_TAPCELL_ROW_33_325 VSS VDD sky130_fd_sc_hd__tapvpwrvgnd_1
XTAP_TAPCELL_ROW_33_326 VSS VDD sky130_fd_sc_hd__tapvpwrvgnd_1
XTAP_TAPCELL_ROW_33_327 VSS VDD sky130_fd_sc_hd__tapvpwrvgnd_1
XTAP_TAPCELL_ROW_33_328 VSS VDD sky130_fd_sc_hd__tapvpwrvgnd_1
XTAP_TAPCELL_ROW_33_329 VSS VDD sky130_fd_sc_hd__tapvpwrvgnd_1
XTAP_TAPCELL_ROW_33_330 VSS VDD sky130_fd_sc_hd__tapvpwrvgnd_1
XTAP_TAPCELL_ROW_33_331 VSS VDD sky130_fd_sc_hd__tapvpwrvgnd_1
XTAP_TAPCELL_ROW_34_332 VSS VDD sky130_fd_sc_hd__tapvpwrvgnd_1
XTAP_TAPCELL_ROW_34_333 VSS VDD sky130_fd_sc_hd__tapvpwrvgnd_1
XTAP_TAPCELL_ROW_34_334 VSS VDD sky130_fd_sc_hd__tapvpwrvgnd_1
XTAP_TAPCELL_ROW_34_335 VSS VDD sky130_fd_sc_hd__tapvpwrvgnd_1
XTAP_TAPCELL_ROW_34_336 VSS VDD sky130_fd_sc_hd__tapvpwrvgnd_1
XTAP_TAPCELL_ROW_34_337 VSS VDD sky130_fd_sc_hd__tapvpwrvgnd_1
XTAP_TAPCELL_ROW_34_338 VSS VDD sky130_fd_sc_hd__tapvpwrvgnd_1
XTAP_TAPCELL_ROW_34_339 VSS VDD sky130_fd_sc_hd__tapvpwrvgnd_1
XTAP_TAPCELL_ROW_34_340 VSS VDD sky130_fd_sc_hd__tapvpwrvgnd_1
XTAP_TAPCELL_ROW_34_341 VSS VDD sky130_fd_sc_hd__tapvpwrvgnd_1
XTAP_TAPCELL_ROW_35_342 VSS VDD sky130_fd_sc_hd__tapvpwrvgnd_1
XTAP_TAPCELL_ROW_35_343 VSS VDD sky130_fd_sc_hd__tapvpwrvgnd_1
XTAP_TAPCELL_ROW_35_344 VSS VDD sky130_fd_sc_hd__tapvpwrvgnd_1
XTAP_TAPCELL_ROW_35_345 VSS VDD sky130_fd_sc_hd__tapvpwrvgnd_1
XTAP_TAPCELL_ROW_35_346 VSS VDD sky130_fd_sc_hd__tapvpwrvgnd_1
XTAP_TAPCELL_ROW_35_347 VSS VDD sky130_fd_sc_hd__tapvpwrvgnd_1
XTAP_TAPCELL_ROW_35_348 VSS VDD sky130_fd_sc_hd__tapvpwrvgnd_1
XTAP_TAPCELL_ROW_35_349 VSS VDD sky130_fd_sc_hd__tapvpwrvgnd_1
XTAP_TAPCELL_ROW_35_350 VSS VDD sky130_fd_sc_hd__tapvpwrvgnd_1
XTAP_TAPCELL_ROW_36_351 VSS VDD sky130_fd_sc_hd__tapvpwrvgnd_1
XTAP_TAPCELL_ROW_36_352 VSS VDD sky130_fd_sc_hd__tapvpwrvgnd_1
XTAP_TAPCELL_ROW_36_353 VSS VDD sky130_fd_sc_hd__tapvpwrvgnd_1
XTAP_TAPCELL_ROW_36_354 VSS VDD sky130_fd_sc_hd__tapvpwrvgnd_1
XTAP_TAPCELL_ROW_36_355 VSS VDD sky130_fd_sc_hd__tapvpwrvgnd_1
XTAP_TAPCELL_ROW_36_356 VSS VDD sky130_fd_sc_hd__tapvpwrvgnd_1
XTAP_TAPCELL_ROW_36_357 VSS VDD sky130_fd_sc_hd__tapvpwrvgnd_1
XTAP_TAPCELL_ROW_36_358 VSS VDD sky130_fd_sc_hd__tapvpwrvgnd_1
XTAP_TAPCELL_ROW_36_359 VSS VDD sky130_fd_sc_hd__tapvpwrvgnd_1
XTAP_TAPCELL_ROW_36_360 VSS VDD sky130_fd_sc_hd__tapvpwrvgnd_1
XTAP_TAPCELL_ROW_37_361 VSS VDD sky130_fd_sc_hd__tapvpwrvgnd_1
XTAP_TAPCELL_ROW_37_362 VSS VDD sky130_fd_sc_hd__tapvpwrvgnd_1
XTAP_TAPCELL_ROW_37_363 VSS VDD sky130_fd_sc_hd__tapvpwrvgnd_1
XTAP_TAPCELL_ROW_37_364 VSS VDD sky130_fd_sc_hd__tapvpwrvgnd_1
XTAP_TAPCELL_ROW_37_365 VSS VDD sky130_fd_sc_hd__tapvpwrvgnd_1
XTAP_TAPCELL_ROW_37_366 VSS VDD sky130_fd_sc_hd__tapvpwrvgnd_1
XTAP_TAPCELL_ROW_37_367 VSS VDD sky130_fd_sc_hd__tapvpwrvgnd_1
XTAP_TAPCELL_ROW_37_368 VSS VDD sky130_fd_sc_hd__tapvpwrvgnd_1
XTAP_TAPCELL_ROW_37_369 VSS VDD sky130_fd_sc_hd__tapvpwrvgnd_1
XTAP_TAPCELL_ROW_38_370 VSS VDD sky130_fd_sc_hd__tapvpwrvgnd_1
XTAP_TAPCELL_ROW_38_371 VSS VDD sky130_fd_sc_hd__tapvpwrvgnd_1
XTAP_TAPCELL_ROW_38_372 VSS VDD sky130_fd_sc_hd__tapvpwrvgnd_1
XTAP_TAPCELL_ROW_38_373 VSS VDD sky130_fd_sc_hd__tapvpwrvgnd_1
XTAP_TAPCELL_ROW_38_374 VSS VDD sky130_fd_sc_hd__tapvpwrvgnd_1
XTAP_TAPCELL_ROW_38_375 VSS VDD sky130_fd_sc_hd__tapvpwrvgnd_1
XTAP_TAPCELL_ROW_38_376 VSS VDD sky130_fd_sc_hd__tapvpwrvgnd_1
XTAP_TAPCELL_ROW_38_377 VSS VDD sky130_fd_sc_hd__tapvpwrvgnd_1
XTAP_TAPCELL_ROW_38_378 VSS VDD sky130_fd_sc_hd__tapvpwrvgnd_1
XTAP_TAPCELL_ROW_38_379 VSS VDD sky130_fd_sc_hd__tapvpwrvgnd_1
XTAP_TAPCELL_ROW_39_380 VSS VDD sky130_fd_sc_hd__tapvpwrvgnd_1
XTAP_TAPCELL_ROW_39_381 VSS VDD sky130_fd_sc_hd__tapvpwrvgnd_1
XTAP_TAPCELL_ROW_39_382 VSS VDD sky130_fd_sc_hd__tapvpwrvgnd_1
XTAP_TAPCELL_ROW_39_383 VSS VDD sky130_fd_sc_hd__tapvpwrvgnd_1
XTAP_TAPCELL_ROW_39_384 VSS VDD sky130_fd_sc_hd__tapvpwrvgnd_1
XTAP_TAPCELL_ROW_39_385 VSS VDD sky130_fd_sc_hd__tapvpwrvgnd_1
XTAP_TAPCELL_ROW_39_386 VSS VDD sky130_fd_sc_hd__tapvpwrvgnd_1
XTAP_TAPCELL_ROW_39_387 VSS VDD sky130_fd_sc_hd__tapvpwrvgnd_1
XTAP_TAPCELL_ROW_39_388 VSS VDD sky130_fd_sc_hd__tapvpwrvgnd_1
XTAP_TAPCELL_ROW_40_389 VSS VDD sky130_fd_sc_hd__tapvpwrvgnd_1
XTAP_TAPCELL_ROW_40_390 VSS VDD sky130_fd_sc_hd__tapvpwrvgnd_1
XTAP_TAPCELL_ROW_40_391 VSS VDD sky130_fd_sc_hd__tapvpwrvgnd_1
XTAP_TAPCELL_ROW_40_392 VSS VDD sky130_fd_sc_hd__tapvpwrvgnd_1
XTAP_TAPCELL_ROW_40_393 VSS VDD sky130_fd_sc_hd__tapvpwrvgnd_1
XTAP_TAPCELL_ROW_40_394 VSS VDD sky130_fd_sc_hd__tapvpwrvgnd_1
XTAP_TAPCELL_ROW_40_395 VSS VDD sky130_fd_sc_hd__tapvpwrvgnd_1
XTAP_TAPCELL_ROW_40_396 VSS VDD sky130_fd_sc_hd__tapvpwrvgnd_1
XTAP_TAPCELL_ROW_40_397 VSS VDD sky130_fd_sc_hd__tapvpwrvgnd_1
XTAP_TAPCELL_ROW_40_398 VSS VDD sky130_fd_sc_hd__tapvpwrvgnd_1
XTAP_TAPCELL_ROW_41_399 VSS VDD sky130_fd_sc_hd__tapvpwrvgnd_1
XTAP_TAPCELL_ROW_41_400 VSS VDD sky130_fd_sc_hd__tapvpwrvgnd_1
XTAP_TAPCELL_ROW_41_401 VSS VDD sky130_fd_sc_hd__tapvpwrvgnd_1
XTAP_TAPCELL_ROW_41_402 VSS VDD sky130_fd_sc_hd__tapvpwrvgnd_1
XTAP_TAPCELL_ROW_41_403 VSS VDD sky130_fd_sc_hd__tapvpwrvgnd_1
XTAP_TAPCELL_ROW_41_404 VSS VDD sky130_fd_sc_hd__tapvpwrvgnd_1
XTAP_TAPCELL_ROW_41_405 VSS VDD sky130_fd_sc_hd__tapvpwrvgnd_1
XTAP_TAPCELL_ROW_41_406 VSS VDD sky130_fd_sc_hd__tapvpwrvgnd_1
XTAP_TAPCELL_ROW_41_407 VSS VDD sky130_fd_sc_hd__tapvpwrvgnd_1
XTAP_TAPCELL_ROW_42_408 VSS VDD sky130_fd_sc_hd__tapvpwrvgnd_1
XTAP_TAPCELL_ROW_42_409 VSS VDD sky130_fd_sc_hd__tapvpwrvgnd_1
XTAP_TAPCELL_ROW_42_410 VSS VDD sky130_fd_sc_hd__tapvpwrvgnd_1
XTAP_TAPCELL_ROW_42_411 VSS VDD sky130_fd_sc_hd__tapvpwrvgnd_1
XTAP_TAPCELL_ROW_42_412 VSS VDD sky130_fd_sc_hd__tapvpwrvgnd_1
XTAP_TAPCELL_ROW_42_413 VSS VDD sky130_fd_sc_hd__tapvpwrvgnd_1
XTAP_TAPCELL_ROW_42_414 VSS VDD sky130_fd_sc_hd__tapvpwrvgnd_1
XTAP_TAPCELL_ROW_42_415 VSS VDD sky130_fd_sc_hd__tapvpwrvgnd_1
XTAP_TAPCELL_ROW_42_416 VSS VDD sky130_fd_sc_hd__tapvpwrvgnd_1
XTAP_TAPCELL_ROW_42_417 VSS VDD sky130_fd_sc_hd__tapvpwrvgnd_1
XTAP_TAPCELL_ROW_43_418 VSS VDD sky130_fd_sc_hd__tapvpwrvgnd_1
XTAP_TAPCELL_ROW_43_419 VSS VDD sky130_fd_sc_hd__tapvpwrvgnd_1
XTAP_TAPCELL_ROW_43_420 VSS VDD sky130_fd_sc_hd__tapvpwrvgnd_1
XTAP_TAPCELL_ROW_43_421 VSS VDD sky130_fd_sc_hd__tapvpwrvgnd_1
XTAP_TAPCELL_ROW_43_422 VSS VDD sky130_fd_sc_hd__tapvpwrvgnd_1
XTAP_TAPCELL_ROW_43_423 VSS VDD sky130_fd_sc_hd__tapvpwrvgnd_1
XTAP_TAPCELL_ROW_43_424 VSS VDD sky130_fd_sc_hd__tapvpwrvgnd_1
XTAP_TAPCELL_ROW_43_425 VSS VDD sky130_fd_sc_hd__tapvpwrvgnd_1
XTAP_TAPCELL_ROW_43_426 VSS VDD sky130_fd_sc_hd__tapvpwrvgnd_1
XTAP_TAPCELL_ROW_44_427 VSS VDD sky130_fd_sc_hd__tapvpwrvgnd_1
XTAP_TAPCELL_ROW_44_428 VSS VDD sky130_fd_sc_hd__tapvpwrvgnd_1
XTAP_TAPCELL_ROW_44_429 VSS VDD sky130_fd_sc_hd__tapvpwrvgnd_1
XTAP_TAPCELL_ROW_44_430 VSS VDD sky130_fd_sc_hd__tapvpwrvgnd_1
XTAP_TAPCELL_ROW_44_431 VSS VDD sky130_fd_sc_hd__tapvpwrvgnd_1
XTAP_TAPCELL_ROW_44_432 VSS VDD sky130_fd_sc_hd__tapvpwrvgnd_1
XTAP_TAPCELL_ROW_44_433 VSS VDD sky130_fd_sc_hd__tapvpwrvgnd_1
XTAP_TAPCELL_ROW_44_434 VSS VDD sky130_fd_sc_hd__tapvpwrvgnd_1
XTAP_TAPCELL_ROW_44_435 VSS VDD sky130_fd_sc_hd__tapvpwrvgnd_1
XTAP_TAPCELL_ROW_44_436 VSS VDD sky130_fd_sc_hd__tapvpwrvgnd_1
XTAP_TAPCELL_ROW_45_437 VSS VDD sky130_fd_sc_hd__tapvpwrvgnd_1
XTAP_TAPCELL_ROW_45_438 VSS VDD sky130_fd_sc_hd__tapvpwrvgnd_1
XTAP_TAPCELL_ROW_45_439 VSS VDD sky130_fd_sc_hd__tapvpwrvgnd_1
XTAP_TAPCELL_ROW_45_440 VSS VDD sky130_fd_sc_hd__tapvpwrvgnd_1
XTAP_TAPCELL_ROW_45_441 VSS VDD sky130_fd_sc_hd__tapvpwrvgnd_1
XTAP_TAPCELL_ROW_45_442 VSS VDD sky130_fd_sc_hd__tapvpwrvgnd_1
XTAP_TAPCELL_ROW_45_443 VSS VDD sky130_fd_sc_hd__tapvpwrvgnd_1
XTAP_TAPCELL_ROW_45_444 VSS VDD sky130_fd_sc_hd__tapvpwrvgnd_1
XTAP_TAPCELL_ROW_45_445 VSS VDD sky130_fd_sc_hd__tapvpwrvgnd_1
XTAP_TAPCELL_ROW_46_446 VSS VDD sky130_fd_sc_hd__tapvpwrvgnd_1
XTAP_TAPCELL_ROW_46_447 VSS VDD sky130_fd_sc_hd__tapvpwrvgnd_1
XTAP_TAPCELL_ROW_46_448 VSS VDD sky130_fd_sc_hd__tapvpwrvgnd_1
XTAP_TAPCELL_ROW_46_449 VSS VDD sky130_fd_sc_hd__tapvpwrvgnd_1
XTAP_TAPCELL_ROW_46_450 VSS VDD sky130_fd_sc_hd__tapvpwrvgnd_1
XTAP_TAPCELL_ROW_46_451 VSS VDD sky130_fd_sc_hd__tapvpwrvgnd_1
XTAP_TAPCELL_ROW_46_452 VSS VDD sky130_fd_sc_hd__tapvpwrvgnd_1
XTAP_TAPCELL_ROW_46_453 VSS VDD sky130_fd_sc_hd__tapvpwrvgnd_1
XTAP_TAPCELL_ROW_46_454 VSS VDD sky130_fd_sc_hd__tapvpwrvgnd_1
XTAP_TAPCELL_ROW_46_455 VSS VDD sky130_fd_sc_hd__tapvpwrvgnd_1
XTAP_TAPCELL_ROW_47_456 VSS VDD sky130_fd_sc_hd__tapvpwrvgnd_1
XTAP_TAPCELL_ROW_47_457 VSS VDD sky130_fd_sc_hd__tapvpwrvgnd_1
XTAP_TAPCELL_ROW_47_458 VSS VDD sky130_fd_sc_hd__tapvpwrvgnd_1
XTAP_TAPCELL_ROW_47_459 VSS VDD sky130_fd_sc_hd__tapvpwrvgnd_1
XTAP_TAPCELL_ROW_47_460 VSS VDD sky130_fd_sc_hd__tapvpwrvgnd_1
XTAP_TAPCELL_ROW_47_461 VSS VDD sky130_fd_sc_hd__tapvpwrvgnd_1
XTAP_TAPCELL_ROW_47_462 VSS VDD sky130_fd_sc_hd__tapvpwrvgnd_1
XTAP_TAPCELL_ROW_47_463 VSS VDD sky130_fd_sc_hd__tapvpwrvgnd_1
XTAP_TAPCELL_ROW_47_464 VSS VDD sky130_fd_sc_hd__tapvpwrvgnd_1
XTAP_TAPCELL_ROW_48_465 VSS VDD sky130_fd_sc_hd__tapvpwrvgnd_1
XTAP_TAPCELL_ROW_48_466 VSS VDD sky130_fd_sc_hd__tapvpwrvgnd_1
XTAP_TAPCELL_ROW_48_467 VSS VDD sky130_fd_sc_hd__tapvpwrvgnd_1
XTAP_TAPCELL_ROW_48_468 VSS VDD sky130_fd_sc_hd__tapvpwrvgnd_1
XTAP_TAPCELL_ROW_48_469 VSS VDD sky130_fd_sc_hd__tapvpwrvgnd_1
XTAP_TAPCELL_ROW_48_470 VSS VDD sky130_fd_sc_hd__tapvpwrvgnd_1
XTAP_TAPCELL_ROW_48_471 VSS VDD sky130_fd_sc_hd__tapvpwrvgnd_1
XTAP_TAPCELL_ROW_48_472 VSS VDD sky130_fd_sc_hd__tapvpwrvgnd_1
XTAP_TAPCELL_ROW_48_473 VSS VDD sky130_fd_sc_hd__tapvpwrvgnd_1
XTAP_TAPCELL_ROW_48_474 VSS VDD sky130_fd_sc_hd__tapvpwrvgnd_1
XTAP_TAPCELL_ROW_49_475 VSS VDD sky130_fd_sc_hd__tapvpwrvgnd_1
XTAP_TAPCELL_ROW_49_476 VSS VDD sky130_fd_sc_hd__tapvpwrvgnd_1
XTAP_TAPCELL_ROW_49_477 VSS VDD sky130_fd_sc_hd__tapvpwrvgnd_1
XTAP_TAPCELL_ROW_49_478 VSS VDD sky130_fd_sc_hd__tapvpwrvgnd_1
XTAP_TAPCELL_ROW_49_479 VSS VDD sky130_fd_sc_hd__tapvpwrvgnd_1
XTAP_TAPCELL_ROW_49_480 VSS VDD sky130_fd_sc_hd__tapvpwrvgnd_1
XTAP_TAPCELL_ROW_49_481 VSS VDD sky130_fd_sc_hd__tapvpwrvgnd_1
XTAP_TAPCELL_ROW_49_482 VSS VDD sky130_fd_sc_hd__tapvpwrvgnd_1
XTAP_TAPCELL_ROW_49_483 VSS VDD sky130_fd_sc_hd__tapvpwrvgnd_1
XTAP_TAPCELL_ROW_50_484 VSS VDD sky130_fd_sc_hd__tapvpwrvgnd_1
XTAP_TAPCELL_ROW_50_485 VSS VDD sky130_fd_sc_hd__tapvpwrvgnd_1
XTAP_TAPCELL_ROW_50_486 VSS VDD sky130_fd_sc_hd__tapvpwrvgnd_1
XTAP_TAPCELL_ROW_50_487 VSS VDD sky130_fd_sc_hd__tapvpwrvgnd_1
XTAP_TAPCELL_ROW_50_488 VSS VDD sky130_fd_sc_hd__tapvpwrvgnd_1
XTAP_TAPCELL_ROW_50_489 VSS VDD sky130_fd_sc_hd__tapvpwrvgnd_1
XTAP_TAPCELL_ROW_50_490 VSS VDD sky130_fd_sc_hd__tapvpwrvgnd_1
XTAP_TAPCELL_ROW_50_491 VSS VDD sky130_fd_sc_hd__tapvpwrvgnd_1
XTAP_TAPCELL_ROW_50_492 VSS VDD sky130_fd_sc_hd__tapvpwrvgnd_1
XTAP_TAPCELL_ROW_50_493 VSS VDD sky130_fd_sc_hd__tapvpwrvgnd_1
XTAP_TAPCELL_ROW_51_494 VSS VDD sky130_fd_sc_hd__tapvpwrvgnd_1
XTAP_TAPCELL_ROW_51_495 VSS VDD sky130_fd_sc_hd__tapvpwrvgnd_1
XTAP_TAPCELL_ROW_51_496 VSS VDD sky130_fd_sc_hd__tapvpwrvgnd_1
XTAP_TAPCELL_ROW_51_497 VSS VDD sky130_fd_sc_hd__tapvpwrvgnd_1
XTAP_TAPCELL_ROW_51_498 VSS VDD sky130_fd_sc_hd__tapvpwrvgnd_1
XTAP_TAPCELL_ROW_51_499 VSS VDD sky130_fd_sc_hd__tapvpwrvgnd_1
XTAP_TAPCELL_ROW_51_500 VSS VDD sky130_fd_sc_hd__tapvpwrvgnd_1
XTAP_TAPCELL_ROW_51_501 VSS VDD sky130_fd_sc_hd__tapvpwrvgnd_1
XTAP_TAPCELL_ROW_51_502 VSS VDD sky130_fd_sc_hd__tapvpwrvgnd_1
XTAP_TAPCELL_ROW_52_503 VSS VDD sky130_fd_sc_hd__tapvpwrvgnd_1
XTAP_TAPCELL_ROW_52_504 VSS VDD sky130_fd_sc_hd__tapvpwrvgnd_1
XTAP_TAPCELL_ROW_52_505 VSS VDD sky130_fd_sc_hd__tapvpwrvgnd_1
XTAP_TAPCELL_ROW_52_506 VSS VDD sky130_fd_sc_hd__tapvpwrvgnd_1
XTAP_TAPCELL_ROW_52_507 VSS VDD sky130_fd_sc_hd__tapvpwrvgnd_1
XTAP_TAPCELL_ROW_52_508 VSS VDD sky130_fd_sc_hd__tapvpwrvgnd_1
XTAP_TAPCELL_ROW_52_509 VSS VDD sky130_fd_sc_hd__tapvpwrvgnd_1
XTAP_TAPCELL_ROW_52_510 VSS VDD sky130_fd_sc_hd__tapvpwrvgnd_1
XTAP_TAPCELL_ROW_52_511 VSS VDD sky130_fd_sc_hd__tapvpwrvgnd_1
XTAP_TAPCELL_ROW_52_512 VSS VDD sky130_fd_sc_hd__tapvpwrvgnd_1
XTAP_TAPCELL_ROW_53_513 VSS VDD sky130_fd_sc_hd__tapvpwrvgnd_1
XTAP_TAPCELL_ROW_53_514 VSS VDD sky130_fd_sc_hd__tapvpwrvgnd_1
XTAP_TAPCELL_ROW_53_515 VSS VDD sky130_fd_sc_hd__tapvpwrvgnd_1
XTAP_TAPCELL_ROW_53_516 VSS VDD sky130_fd_sc_hd__tapvpwrvgnd_1
XTAP_TAPCELL_ROW_53_517 VSS VDD sky130_fd_sc_hd__tapvpwrvgnd_1
XTAP_TAPCELL_ROW_53_518 VSS VDD sky130_fd_sc_hd__tapvpwrvgnd_1
XTAP_TAPCELL_ROW_53_519 VSS VDD sky130_fd_sc_hd__tapvpwrvgnd_1
XTAP_TAPCELL_ROW_53_520 VSS VDD sky130_fd_sc_hd__tapvpwrvgnd_1
XTAP_TAPCELL_ROW_53_521 VSS VDD sky130_fd_sc_hd__tapvpwrvgnd_1
XTAP_TAPCELL_ROW_54_522 VSS VDD sky130_fd_sc_hd__tapvpwrvgnd_1
XTAP_TAPCELL_ROW_54_523 VSS VDD sky130_fd_sc_hd__tapvpwrvgnd_1
XTAP_TAPCELL_ROW_54_524 VSS VDD sky130_fd_sc_hd__tapvpwrvgnd_1
XTAP_TAPCELL_ROW_54_525 VSS VDD sky130_fd_sc_hd__tapvpwrvgnd_1
XTAP_TAPCELL_ROW_54_526 VSS VDD sky130_fd_sc_hd__tapvpwrvgnd_1
XTAP_TAPCELL_ROW_54_527 VSS VDD sky130_fd_sc_hd__tapvpwrvgnd_1
XTAP_TAPCELL_ROW_54_528 VSS VDD sky130_fd_sc_hd__tapvpwrvgnd_1
XTAP_TAPCELL_ROW_54_529 VSS VDD sky130_fd_sc_hd__tapvpwrvgnd_1
XTAP_TAPCELL_ROW_54_530 VSS VDD sky130_fd_sc_hd__tapvpwrvgnd_1
XTAP_TAPCELL_ROW_54_531 VSS VDD sky130_fd_sc_hd__tapvpwrvgnd_1
XTAP_TAPCELL_ROW_55_532 VSS VDD sky130_fd_sc_hd__tapvpwrvgnd_1
XTAP_TAPCELL_ROW_55_533 VSS VDD sky130_fd_sc_hd__tapvpwrvgnd_1
XTAP_TAPCELL_ROW_55_534 VSS VDD sky130_fd_sc_hd__tapvpwrvgnd_1
XTAP_TAPCELL_ROW_55_535 VSS VDD sky130_fd_sc_hd__tapvpwrvgnd_1
XTAP_TAPCELL_ROW_55_536 VSS VDD sky130_fd_sc_hd__tapvpwrvgnd_1
XTAP_TAPCELL_ROW_55_537 VSS VDD sky130_fd_sc_hd__tapvpwrvgnd_1
XTAP_TAPCELL_ROW_55_538 VSS VDD sky130_fd_sc_hd__tapvpwrvgnd_1
XTAP_TAPCELL_ROW_55_539 VSS VDD sky130_fd_sc_hd__tapvpwrvgnd_1
XTAP_TAPCELL_ROW_55_540 VSS VDD sky130_fd_sc_hd__tapvpwrvgnd_1
XTAP_TAPCELL_ROW_56_541 VSS VDD sky130_fd_sc_hd__tapvpwrvgnd_1
XTAP_TAPCELL_ROW_56_542 VSS VDD sky130_fd_sc_hd__tapvpwrvgnd_1
XTAP_TAPCELL_ROW_56_543 VSS VDD sky130_fd_sc_hd__tapvpwrvgnd_1
XTAP_TAPCELL_ROW_56_544 VSS VDD sky130_fd_sc_hd__tapvpwrvgnd_1
XTAP_TAPCELL_ROW_56_545 VSS VDD sky130_fd_sc_hd__tapvpwrvgnd_1
XTAP_TAPCELL_ROW_56_546 VSS VDD sky130_fd_sc_hd__tapvpwrvgnd_1
XTAP_TAPCELL_ROW_56_547 VSS VDD sky130_fd_sc_hd__tapvpwrvgnd_1
XTAP_TAPCELL_ROW_56_548 VSS VDD sky130_fd_sc_hd__tapvpwrvgnd_1
XTAP_TAPCELL_ROW_56_549 VSS VDD sky130_fd_sc_hd__tapvpwrvgnd_1
XTAP_TAPCELL_ROW_56_550 VSS VDD sky130_fd_sc_hd__tapvpwrvgnd_1
XTAP_TAPCELL_ROW_57_551 VSS VDD sky130_fd_sc_hd__tapvpwrvgnd_1
XTAP_TAPCELL_ROW_57_552 VSS VDD sky130_fd_sc_hd__tapvpwrvgnd_1
XTAP_TAPCELL_ROW_57_553 VSS VDD sky130_fd_sc_hd__tapvpwrvgnd_1
XTAP_TAPCELL_ROW_57_554 VSS VDD sky130_fd_sc_hd__tapvpwrvgnd_1
XTAP_TAPCELL_ROW_57_555 VSS VDD sky130_fd_sc_hd__tapvpwrvgnd_1
XTAP_TAPCELL_ROW_57_556 VSS VDD sky130_fd_sc_hd__tapvpwrvgnd_1
XTAP_TAPCELL_ROW_57_557 VSS VDD sky130_fd_sc_hd__tapvpwrvgnd_1
XTAP_TAPCELL_ROW_57_558 VSS VDD sky130_fd_sc_hd__tapvpwrvgnd_1
XTAP_TAPCELL_ROW_57_559 VSS VDD sky130_fd_sc_hd__tapvpwrvgnd_1
XTAP_TAPCELL_ROW_58_560 VSS VDD sky130_fd_sc_hd__tapvpwrvgnd_1
XTAP_TAPCELL_ROW_58_561 VSS VDD sky130_fd_sc_hd__tapvpwrvgnd_1
XTAP_TAPCELL_ROW_58_562 VSS VDD sky130_fd_sc_hd__tapvpwrvgnd_1
XTAP_TAPCELL_ROW_58_563 VSS VDD sky130_fd_sc_hd__tapvpwrvgnd_1
XTAP_TAPCELL_ROW_58_564 VSS VDD sky130_fd_sc_hd__tapvpwrvgnd_1
XTAP_TAPCELL_ROW_58_565 VSS VDD sky130_fd_sc_hd__tapvpwrvgnd_1
XTAP_TAPCELL_ROW_58_566 VSS VDD sky130_fd_sc_hd__tapvpwrvgnd_1
XTAP_TAPCELL_ROW_58_567 VSS VDD sky130_fd_sc_hd__tapvpwrvgnd_1
XTAP_TAPCELL_ROW_58_568 VSS VDD sky130_fd_sc_hd__tapvpwrvgnd_1
XTAP_TAPCELL_ROW_58_569 VSS VDD sky130_fd_sc_hd__tapvpwrvgnd_1
XTAP_TAPCELL_ROW_59_570 VSS VDD sky130_fd_sc_hd__tapvpwrvgnd_1
XTAP_TAPCELL_ROW_59_571 VSS VDD sky130_fd_sc_hd__tapvpwrvgnd_1
XTAP_TAPCELL_ROW_59_572 VSS VDD sky130_fd_sc_hd__tapvpwrvgnd_1
XTAP_TAPCELL_ROW_59_573 VSS VDD sky130_fd_sc_hd__tapvpwrvgnd_1
XTAP_TAPCELL_ROW_59_574 VSS VDD sky130_fd_sc_hd__tapvpwrvgnd_1
XTAP_TAPCELL_ROW_59_575 VSS VDD sky130_fd_sc_hd__tapvpwrvgnd_1
XTAP_TAPCELL_ROW_59_576 VSS VDD sky130_fd_sc_hd__tapvpwrvgnd_1
XTAP_TAPCELL_ROW_59_577 VSS VDD sky130_fd_sc_hd__tapvpwrvgnd_1
XTAP_TAPCELL_ROW_59_578 VSS VDD sky130_fd_sc_hd__tapvpwrvgnd_1
XTAP_TAPCELL_ROW_60_579 VSS VDD sky130_fd_sc_hd__tapvpwrvgnd_1
XTAP_TAPCELL_ROW_60_580 VSS VDD sky130_fd_sc_hd__tapvpwrvgnd_1
XTAP_TAPCELL_ROW_60_581 VSS VDD sky130_fd_sc_hd__tapvpwrvgnd_1
XTAP_TAPCELL_ROW_60_582 VSS VDD sky130_fd_sc_hd__tapvpwrvgnd_1
XTAP_TAPCELL_ROW_60_583 VSS VDD sky130_fd_sc_hd__tapvpwrvgnd_1
XTAP_TAPCELL_ROW_60_584 VSS VDD sky130_fd_sc_hd__tapvpwrvgnd_1
XTAP_TAPCELL_ROW_60_585 VSS VDD sky130_fd_sc_hd__tapvpwrvgnd_1
XTAP_TAPCELL_ROW_60_586 VSS VDD sky130_fd_sc_hd__tapvpwrvgnd_1
XTAP_TAPCELL_ROW_60_587 VSS VDD sky130_fd_sc_hd__tapvpwrvgnd_1
XTAP_TAPCELL_ROW_60_588 VSS VDD sky130_fd_sc_hd__tapvpwrvgnd_1
XTAP_TAPCELL_ROW_61_589 VSS VDD sky130_fd_sc_hd__tapvpwrvgnd_1
XTAP_TAPCELL_ROW_61_590 VSS VDD sky130_fd_sc_hd__tapvpwrvgnd_1
XTAP_TAPCELL_ROW_61_591 VSS VDD sky130_fd_sc_hd__tapvpwrvgnd_1
XTAP_TAPCELL_ROW_61_592 VSS VDD sky130_fd_sc_hd__tapvpwrvgnd_1
XTAP_TAPCELL_ROW_61_593 VSS VDD sky130_fd_sc_hd__tapvpwrvgnd_1
XTAP_TAPCELL_ROW_61_594 VSS VDD sky130_fd_sc_hd__tapvpwrvgnd_1
XTAP_TAPCELL_ROW_61_595 VSS VDD sky130_fd_sc_hd__tapvpwrvgnd_1
XTAP_TAPCELL_ROW_61_596 VSS VDD sky130_fd_sc_hd__tapvpwrvgnd_1
XTAP_TAPCELL_ROW_61_597 VSS VDD sky130_fd_sc_hd__tapvpwrvgnd_1
XTAP_TAPCELL_ROW_62_598 VSS VDD sky130_fd_sc_hd__tapvpwrvgnd_1
XTAP_TAPCELL_ROW_62_599 VSS VDD sky130_fd_sc_hd__tapvpwrvgnd_1
XTAP_TAPCELL_ROW_62_600 VSS VDD sky130_fd_sc_hd__tapvpwrvgnd_1
XTAP_TAPCELL_ROW_62_601 VSS VDD sky130_fd_sc_hd__tapvpwrvgnd_1
XTAP_TAPCELL_ROW_62_602 VSS VDD sky130_fd_sc_hd__tapvpwrvgnd_1
XTAP_TAPCELL_ROW_62_603 VSS VDD sky130_fd_sc_hd__tapvpwrvgnd_1
XTAP_TAPCELL_ROW_62_604 VSS VDD sky130_fd_sc_hd__tapvpwrvgnd_1
XTAP_TAPCELL_ROW_62_605 VSS VDD sky130_fd_sc_hd__tapvpwrvgnd_1
XTAP_TAPCELL_ROW_62_606 VSS VDD sky130_fd_sc_hd__tapvpwrvgnd_1
XTAP_TAPCELL_ROW_62_607 VSS VDD sky130_fd_sc_hd__tapvpwrvgnd_1
XTAP_TAPCELL_ROW_63_608 VSS VDD sky130_fd_sc_hd__tapvpwrvgnd_1
XTAP_TAPCELL_ROW_63_609 VSS VDD sky130_fd_sc_hd__tapvpwrvgnd_1
XTAP_TAPCELL_ROW_63_610 VSS VDD sky130_fd_sc_hd__tapvpwrvgnd_1
XTAP_TAPCELL_ROW_63_611 VSS VDD sky130_fd_sc_hd__tapvpwrvgnd_1
XTAP_TAPCELL_ROW_63_612 VSS VDD sky130_fd_sc_hd__tapvpwrvgnd_1
XTAP_TAPCELL_ROW_63_613 VSS VDD sky130_fd_sc_hd__tapvpwrvgnd_1
XTAP_TAPCELL_ROW_63_614 VSS VDD sky130_fd_sc_hd__tapvpwrvgnd_1
XTAP_TAPCELL_ROW_63_615 VSS VDD sky130_fd_sc_hd__tapvpwrvgnd_1
XTAP_TAPCELL_ROW_63_616 VSS VDD sky130_fd_sc_hd__tapvpwrvgnd_1
XTAP_TAPCELL_ROW_64_617 VSS VDD sky130_fd_sc_hd__tapvpwrvgnd_1
XTAP_TAPCELL_ROW_64_618 VSS VDD sky130_fd_sc_hd__tapvpwrvgnd_1
XTAP_TAPCELL_ROW_64_619 VSS VDD sky130_fd_sc_hd__tapvpwrvgnd_1
XTAP_TAPCELL_ROW_64_620 VSS VDD sky130_fd_sc_hd__tapvpwrvgnd_1
XTAP_TAPCELL_ROW_64_621 VSS VDD sky130_fd_sc_hd__tapvpwrvgnd_1
XTAP_TAPCELL_ROW_64_622 VSS VDD sky130_fd_sc_hd__tapvpwrvgnd_1
XTAP_TAPCELL_ROW_64_623 VSS VDD sky130_fd_sc_hd__tapvpwrvgnd_1
XTAP_TAPCELL_ROW_64_624 VSS VDD sky130_fd_sc_hd__tapvpwrvgnd_1
XTAP_TAPCELL_ROW_64_625 VSS VDD sky130_fd_sc_hd__tapvpwrvgnd_1
XTAP_TAPCELL_ROW_64_626 VSS VDD sky130_fd_sc_hd__tapvpwrvgnd_1
XTAP_TAPCELL_ROW_65_627 VSS VDD sky130_fd_sc_hd__tapvpwrvgnd_1
XTAP_TAPCELL_ROW_65_628 VSS VDD sky130_fd_sc_hd__tapvpwrvgnd_1
XTAP_TAPCELL_ROW_65_629 VSS VDD sky130_fd_sc_hd__tapvpwrvgnd_1
XTAP_TAPCELL_ROW_65_630 VSS VDD sky130_fd_sc_hd__tapvpwrvgnd_1
XTAP_TAPCELL_ROW_65_631 VSS VDD sky130_fd_sc_hd__tapvpwrvgnd_1
XTAP_TAPCELL_ROW_65_632 VSS VDD sky130_fd_sc_hd__tapvpwrvgnd_1
XTAP_TAPCELL_ROW_65_633 VSS VDD sky130_fd_sc_hd__tapvpwrvgnd_1
XTAP_TAPCELL_ROW_65_634 VSS VDD sky130_fd_sc_hd__tapvpwrvgnd_1
XTAP_TAPCELL_ROW_65_635 VSS VDD sky130_fd_sc_hd__tapvpwrvgnd_1
XTAP_TAPCELL_ROW_66_636 VSS VDD sky130_fd_sc_hd__tapvpwrvgnd_1
XTAP_TAPCELL_ROW_66_637 VSS VDD sky130_fd_sc_hd__tapvpwrvgnd_1
XTAP_TAPCELL_ROW_66_638 VSS VDD sky130_fd_sc_hd__tapvpwrvgnd_1
XTAP_TAPCELL_ROW_66_639 VSS VDD sky130_fd_sc_hd__tapvpwrvgnd_1
XTAP_TAPCELL_ROW_66_640 VSS VDD sky130_fd_sc_hd__tapvpwrvgnd_1
XTAP_TAPCELL_ROW_66_641 VSS VDD sky130_fd_sc_hd__tapvpwrvgnd_1
XTAP_TAPCELL_ROW_66_642 VSS VDD sky130_fd_sc_hd__tapvpwrvgnd_1
XTAP_TAPCELL_ROW_66_643 VSS VDD sky130_fd_sc_hd__tapvpwrvgnd_1
XTAP_TAPCELL_ROW_66_644 VSS VDD sky130_fd_sc_hd__tapvpwrvgnd_1
XTAP_TAPCELL_ROW_66_645 VSS VDD sky130_fd_sc_hd__tapvpwrvgnd_1
XTAP_TAPCELL_ROW_67_646 VSS VDD sky130_fd_sc_hd__tapvpwrvgnd_1
XTAP_TAPCELL_ROW_67_647 VSS VDD sky130_fd_sc_hd__tapvpwrvgnd_1
XTAP_TAPCELL_ROW_67_648 VSS VDD sky130_fd_sc_hd__tapvpwrvgnd_1
XTAP_TAPCELL_ROW_67_649 VSS VDD sky130_fd_sc_hd__tapvpwrvgnd_1
XTAP_TAPCELL_ROW_67_650 VSS VDD sky130_fd_sc_hd__tapvpwrvgnd_1
XTAP_TAPCELL_ROW_67_651 VSS VDD sky130_fd_sc_hd__tapvpwrvgnd_1
XTAP_TAPCELL_ROW_67_652 VSS VDD sky130_fd_sc_hd__tapvpwrvgnd_1
XTAP_TAPCELL_ROW_67_653 VSS VDD sky130_fd_sc_hd__tapvpwrvgnd_1
XTAP_TAPCELL_ROW_67_654 VSS VDD sky130_fd_sc_hd__tapvpwrvgnd_1
XTAP_TAPCELL_ROW_68_655 VSS VDD sky130_fd_sc_hd__tapvpwrvgnd_1
XTAP_TAPCELL_ROW_68_656 VSS VDD sky130_fd_sc_hd__tapvpwrvgnd_1
XTAP_TAPCELL_ROW_68_657 VSS VDD sky130_fd_sc_hd__tapvpwrvgnd_1
XTAP_TAPCELL_ROW_68_658 VSS VDD sky130_fd_sc_hd__tapvpwrvgnd_1
XTAP_TAPCELL_ROW_68_659 VSS VDD sky130_fd_sc_hd__tapvpwrvgnd_1
XTAP_TAPCELL_ROW_68_660 VSS VDD sky130_fd_sc_hd__tapvpwrvgnd_1
XTAP_TAPCELL_ROW_68_661 VSS VDD sky130_fd_sc_hd__tapvpwrvgnd_1
XTAP_TAPCELL_ROW_68_662 VSS VDD sky130_fd_sc_hd__tapvpwrvgnd_1
XTAP_TAPCELL_ROW_68_663 VSS VDD sky130_fd_sc_hd__tapvpwrvgnd_1
XTAP_TAPCELL_ROW_68_664 VSS VDD sky130_fd_sc_hd__tapvpwrvgnd_1
XTAP_TAPCELL_ROW_69_665 VSS VDD sky130_fd_sc_hd__tapvpwrvgnd_1
XTAP_TAPCELL_ROW_69_666 VSS VDD sky130_fd_sc_hd__tapvpwrvgnd_1
XTAP_TAPCELL_ROW_69_667 VSS VDD sky130_fd_sc_hd__tapvpwrvgnd_1
XTAP_TAPCELL_ROW_69_668 VSS VDD sky130_fd_sc_hd__tapvpwrvgnd_1
XTAP_TAPCELL_ROW_69_669 VSS VDD sky130_fd_sc_hd__tapvpwrvgnd_1
XTAP_TAPCELL_ROW_69_670 VSS VDD sky130_fd_sc_hd__tapvpwrvgnd_1
XTAP_TAPCELL_ROW_69_671 VSS VDD sky130_fd_sc_hd__tapvpwrvgnd_1
XTAP_TAPCELL_ROW_69_672 VSS VDD sky130_fd_sc_hd__tapvpwrvgnd_1
XTAP_TAPCELL_ROW_69_673 VSS VDD sky130_fd_sc_hd__tapvpwrvgnd_1
XTAP_TAPCELL_ROW_70_674 VSS VDD sky130_fd_sc_hd__tapvpwrvgnd_1
XTAP_TAPCELL_ROW_70_675 VSS VDD sky130_fd_sc_hd__tapvpwrvgnd_1
XTAP_TAPCELL_ROW_70_676 VSS VDD sky130_fd_sc_hd__tapvpwrvgnd_1
XTAP_TAPCELL_ROW_70_677 VSS VDD sky130_fd_sc_hd__tapvpwrvgnd_1
XTAP_TAPCELL_ROW_70_678 VSS VDD sky130_fd_sc_hd__tapvpwrvgnd_1
XTAP_TAPCELL_ROW_70_679 VSS VDD sky130_fd_sc_hd__tapvpwrvgnd_1
XTAP_TAPCELL_ROW_70_680 VSS VDD sky130_fd_sc_hd__tapvpwrvgnd_1
XTAP_TAPCELL_ROW_70_681 VSS VDD sky130_fd_sc_hd__tapvpwrvgnd_1
XTAP_TAPCELL_ROW_70_682 VSS VDD sky130_fd_sc_hd__tapvpwrvgnd_1
XTAP_TAPCELL_ROW_70_683 VSS VDD sky130_fd_sc_hd__tapvpwrvgnd_1
XTAP_TAPCELL_ROW_71_684 VSS VDD sky130_fd_sc_hd__tapvpwrvgnd_1
XTAP_TAPCELL_ROW_71_685 VSS VDD sky130_fd_sc_hd__tapvpwrvgnd_1
XTAP_TAPCELL_ROW_71_686 VSS VDD sky130_fd_sc_hd__tapvpwrvgnd_1
XTAP_TAPCELL_ROW_71_687 VSS VDD sky130_fd_sc_hd__tapvpwrvgnd_1
XTAP_TAPCELL_ROW_71_688 VSS VDD sky130_fd_sc_hd__tapvpwrvgnd_1
XTAP_TAPCELL_ROW_71_689 VSS VDD sky130_fd_sc_hd__tapvpwrvgnd_1
XTAP_TAPCELL_ROW_71_690 VSS VDD sky130_fd_sc_hd__tapvpwrvgnd_1
XTAP_TAPCELL_ROW_71_691 VSS VDD sky130_fd_sc_hd__tapvpwrvgnd_1
XTAP_TAPCELL_ROW_71_692 VSS VDD sky130_fd_sc_hd__tapvpwrvgnd_1
XTAP_TAPCELL_ROW_72_693 VSS VDD sky130_fd_sc_hd__tapvpwrvgnd_1
XTAP_TAPCELL_ROW_72_694 VSS VDD sky130_fd_sc_hd__tapvpwrvgnd_1
XTAP_TAPCELL_ROW_72_695 VSS VDD sky130_fd_sc_hd__tapvpwrvgnd_1
XTAP_TAPCELL_ROW_72_696 VSS VDD sky130_fd_sc_hd__tapvpwrvgnd_1
XTAP_TAPCELL_ROW_72_697 VSS VDD sky130_fd_sc_hd__tapvpwrvgnd_1
XTAP_TAPCELL_ROW_72_698 VSS VDD sky130_fd_sc_hd__tapvpwrvgnd_1
XTAP_TAPCELL_ROW_72_699 VSS VDD sky130_fd_sc_hd__tapvpwrvgnd_1
XTAP_TAPCELL_ROW_72_700 VSS VDD sky130_fd_sc_hd__tapvpwrvgnd_1
XTAP_TAPCELL_ROW_72_701 VSS VDD sky130_fd_sc_hd__tapvpwrvgnd_1
XTAP_TAPCELL_ROW_72_702 VSS VDD sky130_fd_sc_hd__tapvpwrvgnd_1
XTAP_TAPCELL_ROW_73_703 VSS VDD sky130_fd_sc_hd__tapvpwrvgnd_1
XTAP_TAPCELL_ROW_73_704 VSS VDD sky130_fd_sc_hd__tapvpwrvgnd_1
XTAP_TAPCELL_ROW_73_705 VSS VDD sky130_fd_sc_hd__tapvpwrvgnd_1
XTAP_TAPCELL_ROW_73_706 VSS VDD sky130_fd_sc_hd__tapvpwrvgnd_1
XTAP_TAPCELL_ROW_73_707 VSS VDD sky130_fd_sc_hd__tapvpwrvgnd_1
XTAP_TAPCELL_ROW_73_708 VSS VDD sky130_fd_sc_hd__tapvpwrvgnd_1
XTAP_TAPCELL_ROW_73_709 VSS VDD sky130_fd_sc_hd__tapvpwrvgnd_1
XTAP_TAPCELL_ROW_73_710 VSS VDD sky130_fd_sc_hd__tapvpwrvgnd_1
XTAP_TAPCELL_ROW_73_711 VSS VDD sky130_fd_sc_hd__tapvpwrvgnd_1
XTAP_TAPCELL_ROW_74_712 VSS VDD sky130_fd_sc_hd__tapvpwrvgnd_1
XTAP_TAPCELL_ROW_74_713 VSS VDD sky130_fd_sc_hd__tapvpwrvgnd_1
XTAP_TAPCELL_ROW_74_714 VSS VDD sky130_fd_sc_hd__tapvpwrvgnd_1
XTAP_TAPCELL_ROW_74_715 VSS VDD sky130_fd_sc_hd__tapvpwrvgnd_1
XTAP_TAPCELL_ROW_74_716 VSS VDD sky130_fd_sc_hd__tapvpwrvgnd_1
XTAP_TAPCELL_ROW_74_717 VSS VDD sky130_fd_sc_hd__tapvpwrvgnd_1
XTAP_TAPCELL_ROW_74_718 VSS VDD sky130_fd_sc_hd__tapvpwrvgnd_1
XTAP_TAPCELL_ROW_74_719 VSS VDD sky130_fd_sc_hd__tapvpwrvgnd_1
XTAP_TAPCELL_ROW_74_720 VSS VDD sky130_fd_sc_hd__tapvpwrvgnd_1
XTAP_TAPCELL_ROW_74_721 VSS VDD sky130_fd_sc_hd__tapvpwrvgnd_1
XTAP_TAPCELL_ROW_75_722 VSS VDD sky130_fd_sc_hd__tapvpwrvgnd_1
XTAP_TAPCELL_ROW_75_723 VSS VDD sky130_fd_sc_hd__tapvpwrvgnd_1
XTAP_TAPCELL_ROW_75_724 VSS VDD sky130_fd_sc_hd__tapvpwrvgnd_1
XTAP_TAPCELL_ROW_75_725 VSS VDD sky130_fd_sc_hd__tapvpwrvgnd_1
XTAP_TAPCELL_ROW_75_726 VSS VDD sky130_fd_sc_hd__tapvpwrvgnd_1
XTAP_TAPCELL_ROW_75_727 VSS VDD sky130_fd_sc_hd__tapvpwrvgnd_1
XTAP_TAPCELL_ROW_75_728 VSS VDD sky130_fd_sc_hd__tapvpwrvgnd_1
XTAP_TAPCELL_ROW_75_729 VSS VDD sky130_fd_sc_hd__tapvpwrvgnd_1
XTAP_TAPCELL_ROW_75_730 VSS VDD sky130_fd_sc_hd__tapvpwrvgnd_1
XTAP_TAPCELL_ROW_76_731 VSS VDD sky130_fd_sc_hd__tapvpwrvgnd_1
XTAP_TAPCELL_ROW_76_732 VSS VDD sky130_fd_sc_hd__tapvpwrvgnd_1
XTAP_TAPCELL_ROW_76_733 VSS VDD sky130_fd_sc_hd__tapvpwrvgnd_1
XTAP_TAPCELL_ROW_76_734 VSS VDD sky130_fd_sc_hd__tapvpwrvgnd_1
XTAP_TAPCELL_ROW_76_735 VSS VDD sky130_fd_sc_hd__tapvpwrvgnd_1
XTAP_TAPCELL_ROW_76_736 VSS VDD sky130_fd_sc_hd__tapvpwrvgnd_1
XTAP_TAPCELL_ROW_76_737 VSS VDD sky130_fd_sc_hd__tapvpwrvgnd_1
XTAP_TAPCELL_ROW_76_738 VSS VDD sky130_fd_sc_hd__tapvpwrvgnd_1
XTAP_TAPCELL_ROW_76_739 VSS VDD sky130_fd_sc_hd__tapvpwrvgnd_1
XTAP_TAPCELL_ROW_76_740 VSS VDD sky130_fd_sc_hd__tapvpwrvgnd_1
XTAP_TAPCELL_ROW_77_741 VSS VDD sky130_fd_sc_hd__tapvpwrvgnd_1
XTAP_TAPCELL_ROW_77_742 VSS VDD sky130_fd_sc_hd__tapvpwrvgnd_1
XTAP_TAPCELL_ROW_77_743 VSS VDD sky130_fd_sc_hd__tapvpwrvgnd_1
XTAP_TAPCELL_ROW_77_744 VSS VDD sky130_fd_sc_hd__tapvpwrvgnd_1
XTAP_TAPCELL_ROW_77_745 VSS VDD sky130_fd_sc_hd__tapvpwrvgnd_1
XTAP_TAPCELL_ROW_77_746 VSS VDD sky130_fd_sc_hd__tapvpwrvgnd_1
XTAP_TAPCELL_ROW_77_747 VSS VDD sky130_fd_sc_hd__tapvpwrvgnd_1
XTAP_TAPCELL_ROW_77_748 VSS VDD sky130_fd_sc_hd__tapvpwrvgnd_1
XTAP_TAPCELL_ROW_77_749 VSS VDD sky130_fd_sc_hd__tapvpwrvgnd_1
XTAP_TAPCELL_ROW_78_750 VSS VDD sky130_fd_sc_hd__tapvpwrvgnd_1
XTAP_TAPCELL_ROW_78_751 VSS VDD sky130_fd_sc_hd__tapvpwrvgnd_1
XTAP_TAPCELL_ROW_78_752 VSS VDD sky130_fd_sc_hd__tapvpwrvgnd_1
XTAP_TAPCELL_ROW_78_753 VSS VDD sky130_fd_sc_hd__tapvpwrvgnd_1
XTAP_TAPCELL_ROW_78_754 VSS VDD sky130_fd_sc_hd__tapvpwrvgnd_1
XTAP_TAPCELL_ROW_78_755 VSS VDD sky130_fd_sc_hd__tapvpwrvgnd_1
XTAP_TAPCELL_ROW_78_756 VSS VDD sky130_fd_sc_hd__tapvpwrvgnd_1
XTAP_TAPCELL_ROW_78_757 VSS VDD sky130_fd_sc_hd__tapvpwrvgnd_1
XTAP_TAPCELL_ROW_78_758 VSS VDD sky130_fd_sc_hd__tapvpwrvgnd_1
XTAP_TAPCELL_ROW_78_759 VSS VDD sky130_fd_sc_hd__tapvpwrvgnd_1
XTAP_TAPCELL_ROW_79_760 VSS VDD sky130_fd_sc_hd__tapvpwrvgnd_1
XTAP_TAPCELL_ROW_79_761 VSS VDD sky130_fd_sc_hd__tapvpwrvgnd_1
XTAP_TAPCELL_ROW_79_762 VSS VDD sky130_fd_sc_hd__tapvpwrvgnd_1
XTAP_TAPCELL_ROW_79_763 VSS VDD sky130_fd_sc_hd__tapvpwrvgnd_1
XTAP_TAPCELL_ROW_79_764 VSS VDD sky130_fd_sc_hd__tapvpwrvgnd_1
XTAP_TAPCELL_ROW_79_765 VSS VDD sky130_fd_sc_hd__tapvpwrvgnd_1
XTAP_TAPCELL_ROW_79_766 VSS VDD sky130_fd_sc_hd__tapvpwrvgnd_1
XTAP_TAPCELL_ROW_79_767 VSS VDD sky130_fd_sc_hd__tapvpwrvgnd_1
XTAP_TAPCELL_ROW_79_768 VSS VDD sky130_fd_sc_hd__tapvpwrvgnd_1
XTAP_TAPCELL_ROW_80_769 VSS VDD sky130_fd_sc_hd__tapvpwrvgnd_1
XTAP_TAPCELL_ROW_80_770 VSS VDD sky130_fd_sc_hd__tapvpwrvgnd_1
XTAP_TAPCELL_ROW_80_771 VSS VDD sky130_fd_sc_hd__tapvpwrvgnd_1
XTAP_TAPCELL_ROW_80_772 VSS VDD sky130_fd_sc_hd__tapvpwrvgnd_1
XTAP_TAPCELL_ROW_80_773 VSS VDD sky130_fd_sc_hd__tapvpwrvgnd_1
XTAP_TAPCELL_ROW_80_774 VSS VDD sky130_fd_sc_hd__tapvpwrvgnd_1
XTAP_TAPCELL_ROW_80_775 VSS VDD sky130_fd_sc_hd__tapvpwrvgnd_1
XTAP_TAPCELL_ROW_80_776 VSS VDD sky130_fd_sc_hd__tapvpwrvgnd_1
XTAP_TAPCELL_ROW_80_777 VSS VDD sky130_fd_sc_hd__tapvpwrvgnd_1
XTAP_TAPCELL_ROW_80_778 VSS VDD sky130_fd_sc_hd__tapvpwrvgnd_1
XTAP_TAPCELL_ROW_81_779 VSS VDD sky130_fd_sc_hd__tapvpwrvgnd_1
XTAP_TAPCELL_ROW_81_780 VSS VDD sky130_fd_sc_hd__tapvpwrvgnd_1
XTAP_TAPCELL_ROW_81_781 VSS VDD sky130_fd_sc_hd__tapvpwrvgnd_1
XTAP_TAPCELL_ROW_81_782 VSS VDD sky130_fd_sc_hd__tapvpwrvgnd_1
XTAP_TAPCELL_ROW_81_783 VSS VDD sky130_fd_sc_hd__tapvpwrvgnd_1
XTAP_TAPCELL_ROW_81_784 VSS VDD sky130_fd_sc_hd__tapvpwrvgnd_1
XTAP_TAPCELL_ROW_81_785 VSS VDD sky130_fd_sc_hd__tapvpwrvgnd_1
XTAP_TAPCELL_ROW_81_786 VSS VDD sky130_fd_sc_hd__tapvpwrvgnd_1
XTAP_TAPCELL_ROW_81_787 VSS VDD sky130_fd_sc_hd__tapvpwrvgnd_1
XTAP_TAPCELL_ROW_82_788 VSS VDD sky130_fd_sc_hd__tapvpwrvgnd_1
XTAP_TAPCELL_ROW_82_789 VSS VDD sky130_fd_sc_hd__tapvpwrvgnd_1
XTAP_TAPCELL_ROW_82_790 VSS VDD sky130_fd_sc_hd__tapvpwrvgnd_1
XTAP_TAPCELL_ROW_82_791 VSS VDD sky130_fd_sc_hd__tapvpwrvgnd_1
XTAP_TAPCELL_ROW_82_792 VSS VDD sky130_fd_sc_hd__tapvpwrvgnd_1
XTAP_TAPCELL_ROW_82_793 VSS VDD sky130_fd_sc_hd__tapvpwrvgnd_1
XTAP_TAPCELL_ROW_82_794 VSS VDD sky130_fd_sc_hd__tapvpwrvgnd_1
XTAP_TAPCELL_ROW_82_795 VSS VDD sky130_fd_sc_hd__tapvpwrvgnd_1
XTAP_TAPCELL_ROW_82_796 VSS VDD sky130_fd_sc_hd__tapvpwrvgnd_1
XTAP_TAPCELL_ROW_82_797 VSS VDD sky130_fd_sc_hd__tapvpwrvgnd_1
XTAP_TAPCELL_ROW_83_798 VSS VDD sky130_fd_sc_hd__tapvpwrvgnd_1
XTAP_TAPCELL_ROW_83_799 VSS VDD sky130_fd_sc_hd__tapvpwrvgnd_1
XTAP_TAPCELL_ROW_83_800 VSS VDD sky130_fd_sc_hd__tapvpwrvgnd_1
XTAP_TAPCELL_ROW_83_801 VSS VDD sky130_fd_sc_hd__tapvpwrvgnd_1
XTAP_TAPCELL_ROW_83_802 VSS VDD sky130_fd_sc_hd__tapvpwrvgnd_1
XTAP_TAPCELL_ROW_83_803 VSS VDD sky130_fd_sc_hd__tapvpwrvgnd_1
XTAP_TAPCELL_ROW_83_804 VSS VDD sky130_fd_sc_hd__tapvpwrvgnd_1
XTAP_TAPCELL_ROW_83_805 VSS VDD sky130_fd_sc_hd__tapvpwrvgnd_1
XTAP_TAPCELL_ROW_83_806 VSS VDD sky130_fd_sc_hd__tapvpwrvgnd_1
XTAP_TAPCELL_ROW_84_807 VSS VDD sky130_fd_sc_hd__tapvpwrvgnd_1
XTAP_TAPCELL_ROW_84_808 VSS VDD sky130_fd_sc_hd__tapvpwrvgnd_1
XTAP_TAPCELL_ROW_84_809 VSS VDD sky130_fd_sc_hd__tapvpwrvgnd_1
XTAP_TAPCELL_ROW_84_810 VSS VDD sky130_fd_sc_hd__tapvpwrvgnd_1
XTAP_TAPCELL_ROW_84_811 VSS VDD sky130_fd_sc_hd__tapvpwrvgnd_1
XTAP_TAPCELL_ROW_84_812 VSS VDD sky130_fd_sc_hd__tapvpwrvgnd_1
XTAP_TAPCELL_ROW_84_813 VSS VDD sky130_fd_sc_hd__tapvpwrvgnd_1
XTAP_TAPCELL_ROW_84_814 VSS VDD sky130_fd_sc_hd__tapvpwrvgnd_1
XTAP_TAPCELL_ROW_84_815 VSS VDD sky130_fd_sc_hd__tapvpwrvgnd_1
XTAP_TAPCELL_ROW_84_816 VSS VDD sky130_fd_sc_hd__tapvpwrvgnd_1
XTAP_TAPCELL_ROW_85_817 VSS VDD sky130_fd_sc_hd__tapvpwrvgnd_1
XTAP_TAPCELL_ROW_85_818 VSS VDD sky130_fd_sc_hd__tapvpwrvgnd_1
XTAP_TAPCELL_ROW_85_819 VSS VDD sky130_fd_sc_hd__tapvpwrvgnd_1
XTAP_TAPCELL_ROW_85_820 VSS VDD sky130_fd_sc_hd__tapvpwrvgnd_1
XTAP_TAPCELL_ROW_85_821 VSS VDD sky130_fd_sc_hd__tapvpwrvgnd_1
XTAP_TAPCELL_ROW_85_822 VSS VDD sky130_fd_sc_hd__tapvpwrvgnd_1
XTAP_TAPCELL_ROW_85_823 VSS VDD sky130_fd_sc_hd__tapvpwrvgnd_1
XTAP_TAPCELL_ROW_85_824 VSS VDD sky130_fd_sc_hd__tapvpwrvgnd_1
XTAP_TAPCELL_ROW_85_825 VSS VDD sky130_fd_sc_hd__tapvpwrvgnd_1
XTAP_TAPCELL_ROW_86_826 VSS VDD sky130_fd_sc_hd__tapvpwrvgnd_1
XTAP_TAPCELL_ROW_86_827 VSS VDD sky130_fd_sc_hd__tapvpwrvgnd_1
XTAP_TAPCELL_ROW_86_828 VSS VDD sky130_fd_sc_hd__tapvpwrvgnd_1
XTAP_TAPCELL_ROW_86_829 VSS VDD sky130_fd_sc_hd__tapvpwrvgnd_1
XTAP_TAPCELL_ROW_86_830 VSS VDD sky130_fd_sc_hd__tapvpwrvgnd_1
XTAP_TAPCELL_ROW_86_831 VSS VDD sky130_fd_sc_hd__tapvpwrvgnd_1
XTAP_TAPCELL_ROW_86_832 VSS VDD sky130_fd_sc_hd__tapvpwrvgnd_1
XTAP_TAPCELL_ROW_86_833 VSS VDD sky130_fd_sc_hd__tapvpwrvgnd_1
XTAP_TAPCELL_ROW_86_834 VSS VDD sky130_fd_sc_hd__tapvpwrvgnd_1
XTAP_TAPCELL_ROW_86_835 VSS VDD sky130_fd_sc_hd__tapvpwrvgnd_1
XTAP_TAPCELL_ROW_87_836 VSS VDD sky130_fd_sc_hd__tapvpwrvgnd_1
XTAP_TAPCELL_ROW_87_837 VSS VDD sky130_fd_sc_hd__tapvpwrvgnd_1
XTAP_TAPCELL_ROW_87_838 VSS VDD sky130_fd_sc_hd__tapvpwrvgnd_1
XTAP_TAPCELL_ROW_87_839 VSS VDD sky130_fd_sc_hd__tapvpwrvgnd_1
XTAP_TAPCELL_ROW_87_840 VSS VDD sky130_fd_sc_hd__tapvpwrvgnd_1
XTAP_TAPCELL_ROW_87_841 VSS VDD sky130_fd_sc_hd__tapvpwrvgnd_1
XTAP_TAPCELL_ROW_87_842 VSS VDD sky130_fd_sc_hd__tapvpwrvgnd_1
XTAP_TAPCELL_ROW_87_843 VSS VDD sky130_fd_sc_hd__tapvpwrvgnd_1
XTAP_TAPCELL_ROW_87_844 VSS VDD sky130_fd_sc_hd__tapvpwrvgnd_1
XTAP_TAPCELL_ROW_88_845 VSS VDD sky130_fd_sc_hd__tapvpwrvgnd_1
XTAP_TAPCELL_ROW_88_846 VSS VDD sky130_fd_sc_hd__tapvpwrvgnd_1
XTAP_TAPCELL_ROW_88_847 VSS VDD sky130_fd_sc_hd__tapvpwrvgnd_1
XTAP_TAPCELL_ROW_88_848 VSS VDD sky130_fd_sc_hd__tapvpwrvgnd_1
XTAP_TAPCELL_ROW_88_849 VSS VDD sky130_fd_sc_hd__tapvpwrvgnd_1
XTAP_TAPCELL_ROW_88_850 VSS VDD sky130_fd_sc_hd__tapvpwrvgnd_1
XTAP_TAPCELL_ROW_88_851 VSS VDD sky130_fd_sc_hd__tapvpwrvgnd_1
XTAP_TAPCELL_ROW_88_852 VSS VDD sky130_fd_sc_hd__tapvpwrvgnd_1
XTAP_TAPCELL_ROW_88_853 VSS VDD sky130_fd_sc_hd__tapvpwrvgnd_1
XTAP_TAPCELL_ROW_88_854 VSS VDD sky130_fd_sc_hd__tapvpwrvgnd_1
XTAP_TAPCELL_ROW_89_855 VSS VDD sky130_fd_sc_hd__tapvpwrvgnd_1
XTAP_TAPCELL_ROW_89_856 VSS VDD sky130_fd_sc_hd__tapvpwrvgnd_1
XTAP_TAPCELL_ROW_89_857 VSS VDD sky130_fd_sc_hd__tapvpwrvgnd_1
XTAP_TAPCELL_ROW_89_858 VSS VDD sky130_fd_sc_hd__tapvpwrvgnd_1
XTAP_TAPCELL_ROW_89_859 VSS VDD sky130_fd_sc_hd__tapvpwrvgnd_1
XTAP_TAPCELL_ROW_89_860 VSS VDD sky130_fd_sc_hd__tapvpwrvgnd_1
XTAP_TAPCELL_ROW_89_861 VSS VDD sky130_fd_sc_hd__tapvpwrvgnd_1
XTAP_TAPCELL_ROW_89_862 VSS VDD sky130_fd_sc_hd__tapvpwrvgnd_1
XTAP_TAPCELL_ROW_89_863 VSS VDD sky130_fd_sc_hd__tapvpwrvgnd_1
XTAP_TAPCELL_ROW_90_864 VSS VDD sky130_fd_sc_hd__tapvpwrvgnd_1
XTAP_TAPCELL_ROW_90_865 VSS VDD sky130_fd_sc_hd__tapvpwrvgnd_1
XTAP_TAPCELL_ROW_90_866 VSS VDD sky130_fd_sc_hd__tapvpwrvgnd_1
XTAP_TAPCELL_ROW_90_867 VSS VDD sky130_fd_sc_hd__tapvpwrvgnd_1
XTAP_TAPCELL_ROW_90_868 VSS VDD sky130_fd_sc_hd__tapvpwrvgnd_1
XTAP_TAPCELL_ROW_90_869 VSS VDD sky130_fd_sc_hd__tapvpwrvgnd_1
XTAP_TAPCELL_ROW_90_870 VSS VDD sky130_fd_sc_hd__tapvpwrvgnd_1
XTAP_TAPCELL_ROW_90_871 VSS VDD sky130_fd_sc_hd__tapvpwrvgnd_1
XTAP_TAPCELL_ROW_90_872 VSS VDD sky130_fd_sc_hd__tapvpwrvgnd_1
XTAP_TAPCELL_ROW_90_873 VSS VDD sky130_fd_sc_hd__tapvpwrvgnd_1
XTAP_TAPCELL_ROW_91_874 VSS VDD sky130_fd_sc_hd__tapvpwrvgnd_1
XTAP_TAPCELL_ROW_91_875 VSS VDD sky130_fd_sc_hd__tapvpwrvgnd_1
XTAP_TAPCELL_ROW_91_876 VSS VDD sky130_fd_sc_hd__tapvpwrvgnd_1
XTAP_TAPCELL_ROW_91_877 VSS VDD sky130_fd_sc_hd__tapvpwrvgnd_1
XTAP_TAPCELL_ROW_91_878 VSS VDD sky130_fd_sc_hd__tapvpwrvgnd_1
XTAP_TAPCELL_ROW_91_879 VSS VDD sky130_fd_sc_hd__tapvpwrvgnd_1
XTAP_TAPCELL_ROW_91_880 VSS VDD sky130_fd_sc_hd__tapvpwrvgnd_1
XTAP_TAPCELL_ROW_91_881 VSS VDD sky130_fd_sc_hd__tapvpwrvgnd_1
XTAP_TAPCELL_ROW_91_882 VSS VDD sky130_fd_sc_hd__tapvpwrvgnd_1
XTAP_TAPCELL_ROW_92_883 VSS VDD sky130_fd_sc_hd__tapvpwrvgnd_1
XTAP_TAPCELL_ROW_92_884 VSS VDD sky130_fd_sc_hd__tapvpwrvgnd_1
XTAP_TAPCELL_ROW_92_885 VSS VDD sky130_fd_sc_hd__tapvpwrvgnd_1
XTAP_TAPCELL_ROW_92_886 VSS VDD sky130_fd_sc_hd__tapvpwrvgnd_1
XTAP_TAPCELL_ROW_92_887 VSS VDD sky130_fd_sc_hd__tapvpwrvgnd_1
XTAP_TAPCELL_ROW_92_888 VSS VDD sky130_fd_sc_hd__tapvpwrvgnd_1
XTAP_TAPCELL_ROW_92_889 VSS VDD sky130_fd_sc_hd__tapvpwrvgnd_1
XTAP_TAPCELL_ROW_92_890 VSS VDD sky130_fd_sc_hd__tapvpwrvgnd_1
XTAP_TAPCELL_ROW_92_891 VSS VDD sky130_fd_sc_hd__tapvpwrvgnd_1
XTAP_TAPCELL_ROW_92_892 VSS VDD sky130_fd_sc_hd__tapvpwrvgnd_1
XTAP_TAPCELL_ROW_93_893 VSS VDD sky130_fd_sc_hd__tapvpwrvgnd_1
XTAP_TAPCELL_ROW_93_894 VSS VDD sky130_fd_sc_hd__tapvpwrvgnd_1
XTAP_TAPCELL_ROW_93_895 VSS VDD sky130_fd_sc_hd__tapvpwrvgnd_1
XTAP_TAPCELL_ROW_93_896 VSS VDD sky130_fd_sc_hd__tapvpwrvgnd_1
XTAP_TAPCELL_ROW_93_897 VSS VDD sky130_fd_sc_hd__tapvpwrvgnd_1
XTAP_TAPCELL_ROW_93_898 VSS VDD sky130_fd_sc_hd__tapvpwrvgnd_1
XTAP_TAPCELL_ROW_93_899 VSS VDD sky130_fd_sc_hd__tapvpwrvgnd_1
XTAP_TAPCELL_ROW_93_900 VSS VDD sky130_fd_sc_hd__tapvpwrvgnd_1
XTAP_TAPCELL_ROW_93_901 VSS VDD sky130_fd_sc_hd__tapvpwrvgnd_1
XTAP_TAPCELL_ROW_94_902 VSS VDD sky130_fd_sc_hd__tapvpwrvgnd_1
XTAP_TAPCELL_ROW_94_903 VSS VDD sky130_fd_sc_hd__tapvpwrvgnd_1
XTAP_TAPCELL_ROW_94_904 VSS VDD sky130_fd_sc_hd__tapvpwrvgnd_1
XTAP_TAPCELL_ROW_94_905 VSS VDD sky130_fd_sc_hd__tapvpwrvgnd_1
XTAP_TAPCELL_ROW_94_906 VSS VDD sky130_fd_sc_hd__tapvpwrvgnd_1
XTAP_TAPCELL_ROW_94_907 VSS VDD sky130_fd_sc_hd__tapvpwrvgnd_1
XTAP_TAPCELL_ROW_94_908 VSS VDD sky130_fd_sc_hd__tapvpwrvgnd_1
XTAP_TAPCELL_ROW_94_909 VSS VDD sky130_fd_sc_hd__tapvpwrvgnd_1
XTAP_TAPCELL_ROW_94_910 VSS VDD sky130_fd_sc_hd__tapvpwrvgnd_1
XTAP_TAPCELL_ROW_94_911 VSS VDD sky130_fd_sc_hd__tapvpwrvgnd_1
XTAP_TAPCELL_ROW_95_912 VSS VDD sky130_fd_sc_hd__tapvpwrvgnd_1
XTAP_TAPCELL_ROW_95_913 VSS VDD sky130_fd_sc_hd__tapvpwrvgnd_1
XTAP_TAPCELL_ROW_95_914 VSS VDD sky130_fd_sc_hd__tapvpwrvgnd_1
XTAP_TAPCELL_ROW_95_915 VSS VDD sky130_fd_sc_hd__tapvpwrvgnd_1
XTAP_TAPCELL_ROW_95_916 VSS VDD sky130_fd_sc_hd__tapvpwrvgnd_1
XTAP_TAPCELL_ROW_95_917 VSS VDD sky130_fd_sc_hd__tapvpwrvgnd_1
XTAP_TAPCELL_ROW_95_918 VSS VDD sky130_fd_sc_hd__tapvpwrvgnd_1
XTAP_TAPCELL_ROW_95_919 VSS VDD sky130_fd_sc_hd__tapvpwrvgnd_1
XTAP_TAPCELL_ROW_95_920 VSS VDD sky130_fd_sc_hd__tapvpwrvgnd_1
XTAP_TAPCELL_ROW_96_921 VSS VDD sky130_fd_sc_hd__tapvpwrvgnd_1
XTAP_TAPCELL_ROW_96_922 VSS VDD sky130_fd_sc_hd__tapvpwrvgnd_1
XTAP_TAPCELL_ROW_96_923 VSS VDD sky130_fd_sc_hd__tapvpwrvgnd_1
XTAP_TAPCELL_ROW_96_924 VSS VDD sky130_fd_sc_hd__tapvpwrvgnd_1
XTAP_TAPCELL_ROW_96_925 VSS VDD sky130_fd_sc_hd__tapvpwrvgnd_1
XTAP_TAPCELL_ROW_96_926 VSS VDD sky130_fd_sc_hd__tapvpwrvgnd_1
XTAP_TAPCELL_ROW_96_927 VSS VDD sky130_fd_sc_hd__tapvpwrvgnd_1
XTAP_TAPCELL_ROW_96_928 VSS VDD sky130_fd_sc_hd__tapvpwrvgnd_1
XTAP_TAPCELL_ROW_96_929 VSS VDD sky130_fd_sc_hd__tapvpwrvgnd_1
XTAP_TAPCELL_ROW_96_930 VSS VDD sky130_fd_sc_hd__tapvpwrvgnd_1
XTAP_TAPCELL_ROW_97_931 VSS VDD sky130_fd_sc_hd__tapvpwrvgnd_1
XTAP_TAPCELL_ROW_97_932 VSS VDD sky130_fd_sc_hd__tapvpwrvgnd_1
XTAP_TAPCELL_ROW_97_933 VSS VDD sky130_fd_sc_hd__tapvpwrvgnd_1
XTAP_TAPCELL_ROW_97_934 VSS VDD sky130_fd_sc_hd__tapvpwrvgnd_1
XTAP_TAPCELL_ROW_97_935 VSS VDD sky130_fd_sc_hd__tapvpwrvgnd_1
XTAP_TAPCELL_ROW_97_936 VSS VDD sky130_fd_sc_hd__tapvpwrvgnd_1
XTAP_TAPCELL_ROW_97_937 VSS VDD sky130_fd_sc_hd__tapvpwrvgnd_1
XTAP_TAPCELL_ROW_97_938 VSS VDD sky130_fd_sc_hd__tapvpwrvgnd_1
XTAP_TAPCELL_ROW_97_939 VSS VDD sky130_fd_sc_hd__tapvpwrvgnd_1
XTAP_TAPCELL_ROW_98_940 VSS VDD sky130_fd_sc_hd__tapvpwrvgnd_1
XTAP_TAPCELL_ROW_98_941 VSS VDD sky130_fd_sc_hd__tapvpwrvgnd_1
XTAP_TAPCELL_ROW_98_942 VSS VDD sky130_fd_sc_hd__tapvpwrvgnd_1
XTAP_TAPCELL_ROW_98_943 VSS VDD sky130_fd_sc_hd__tapvpwrvgnd_1
XTAP_TAPCELL_ROW_98_944 VSS VDD sky130_fd_sc_hd__tapvpwrvgnd_1
XTAP_TAPCELL_ROW_98_945 VSS VDD sky130_fd_sc_hd__tapvpwrvgnd_1
XTAP_TAPCELL_ROW_98_946 VSS VDD sky130_fd_sc_hd__tapvpwrvgnd_1
XTAP_TAPCELL_ROW_98_947 VSS VDD sky130_fd_sc_hd__tapvpwrvgnd_1
XTAP_TAPCELL_ROW_98_948 VSS VDD sky130_fd_sc_hd__tapvpwrvgnd_1
XTAP_TAPCELL_ROW_98_949 VSS VDD sky130_fd_sc_hd__tapvpwrvgnd_1
XTAP_TAPCELL_ROW_99_950 VSS VDD sky130_fd_sc_hd__tapvpwrvgnd_1
XTAP_TAPCELL_ROW_99_951 VSS VDD sky130_fd_sc_hd__tapvpwrvgnd_1
XTAP_TAPCELL_ROW_99_952 VSS VDD sky130_fd_sc_hd__tapvpwrvgnd_1
XTAP_TAPCELL_ROW_99_953 VSS VDD sky130_fd_sc_hd__tapvpwrvgnd_1
XTAP_TAPCELL_ROW_99_954 VSS VDD sky130_fd_sc_hd__tapvpwrvgnd_1
XTAP_TAPCELL_ROW_99_955 VSS VDD sky130_fd_sc_hd__tapvpwrvgnd_1
XTAP_TAPCELL_ROW_99_956 VSS VDD sky130_fd_sc_hd__tapvpwrvgnd_1
XTAP_TAPCELL_ROW_99_957 VSS VDD sky130_fd_sc_hd__tapvpwrvgnd_1
XTAP_TAPCELL_ROW_99_958 VSS VDD sky130_fd_sc_hd__tapvpwrvgnd_1
XTAP_TAPCELL_ROW_99_959 VSS VDD sky130_fd_sc_hd__tapvpwrvgnd_1
XTAP_TAPCELL_ROW_99_960 VSS VDD sky130_fd_sc_hd__tapvpwrvgnd_1
XTAP_TAPCELL_ROW_99_961 VSS VDD sky130_fd_sc_hd__tapvpwrvgnd_1
XTAP_TAPCELL_ROW_99_962 VSS VDD sky130_fd_sc_hd__tapvpwrvgnd_1
XTAP_TAPCELL_ROW_99_963 VSS VDD sky130_fd_sc_hd__tapvpwrvgnd_1
XTAP_TAPCELL_ROW_99_964 VSS VDD sky130_fd_sc_hd__tapvpwrvgnd_1
XTAP_TAPCELL_ROW_99_965 VSS VDD sky130_fd_sc_hd__tapvpwrvgnd_1
XTAP_TAPCELL_ROW_99_966 VSS VDD sky130_fd_sc_hd__tapvpwrvgnd_1
XTAP_TAPCELL_ROW_99_967 VSS VDD sky130_fd_sc_hd__tapvpwrvgnd_1
XTAP_TAPCELL_ROW_99_968 VSS VDD sky130_fd_sc_hd__tapvpwrvgnd_1
Xoutput123 net123 VSS VSS VDD VDD c11[22] sky130_fd_sc_hd__clkdlybuf4s50_1
Xoutput124 net124 VSS VSS VDD VDD c11[23] sky130_fd_sc_hd__clkdlybuf4s50_1
Xoutput125 net125 VSS VSS VDD VDD c11[2] sky130_fd_sc_hd__clkdlybuf4s50_1
Xoutput126 net126 VSS VSS VDD VDD c11[3] sky130_fd_sc_hd__clkdlybuf4s50_1
Xoutput127 net127 VSS VSS VDD VDD c11[4] sky130_fd_sc_hd__clkdlybuf4s50_1
Xoutput128 net128 VSS VSS VDD VDD c11[5] sky130_fd_sc_hd__clkdlybuf4s50_1
Xoutput129 net129 VSS VSS VDD VDD c11[6] sky130_fd_sc_hd__clkdlybuf4s50_1
Xoutput130 net130 VSS VSS VDD VDD c11[7] sky130_fd_sc_hd__clkdlybuf4s50_1
Xoutput131 net131 VSS VSS VDD VDD c11[8] sky130_fd_sc_hd__clkdlybuf4s50_1
Xoutput132 net132 VSS VSS VDD VDD c11[9] sky130_fd_sc_hd__clkdlybuf4s50_1
Xoutput133 net133 VSS VSS VDD VDD done sky130_fd_sc_hd__clkdlybuf4s50_1
Xplace159 _00664_ VSS VSS VDD VDD net159 sky130_fd_sc_hd__buf_4
Xplace162 net163 VSS VSS VDD VDD net162 sky130_fd_sc_hd__buf_4
Xplace164 net34 VSS VSS VDD VDD net164 sky130_fd_sc_hd__buf_4
Xclkbuf_4_0_0_clk clknet_0_clk VSS VSS VDD VDD clknet_4_0_0_clk
+ sky130_fd_sc_hd__clkbuf_16
Xclkbuf_0_clk clk VSS VSS VDD VDD clknet_0_clk sky130_fd_sc_hd__clkbuf_16
Xplace152 _03128_ VSS VSS VDD VDD net152 sky130_fd_sc_hd__buf_4
Xplace153 _02970_ VSS VSS VDD VDD net153 sky130_fd_sc_hd__buf_4
Xplace154 _02966_ VSS VSS VDD VDD net154 sky130_fd_sc_hd__buf_4
Xplace155 wrapped_design.pe10.valid_out VSS VSS VDD VDD net155
+ sky130_fd_sc_hd__buf_4
Xplace158 wrapped_design.pe00.start_out VSS VSS VDD VDD net158
+ sky130_fd_sc_hd__buf_4
Xplace161 _00491_ VSS VSS VDD VDD net161 sky130_fd_sc_hd__buf_4
Xplace160 net161 VSS VSS VDD VDD net160 sky130_fd_sc_hd__buf_4
Xplace163 net36 VSS VSS VDD VDD net163 sky130_fd_sc_hd__buf_4
Xplace156 wrapped_design.pe00.valid_out VSS VSS VDD VDD net156
+ sky130_fd_sc_hd__buf_4
Xplace157 wrapped_design.pe00.valid_out VSS VSS VDD VDD net157
+ sky130_fd_sc_hd__buf_4
Xclkbuf_4_1_0_clk clknet_0_clk VSS VSS VDD VDD clknet_4_1_0_clk
+ sky130_fd_sc_hd__clkbuf_16
Xclkbuf_4_2_0_clk clknet_0_clk VSS VSS VDD VDD clknet_4_2_0_clk
+ sky130_fd_sc_hd__clkbuf_16
Xclkbuf_4_3_0_clk clknet_0_clk VSS VSS VDD VDD clknet_4_3_0_clk
+ sky130_fd_sc_hd__clkbuf_16
Xclkbuf_4_4_0_clk clknet_0_clk VSS VSS VDD VDD clknet_4_4_0_clk
+ sky130_fd_sc_hd__clkbuf_16
Xclkbuf_4_5_0_clk clknet_0_clk VSS VSS VDD VDD clknet_4_5_0_clk
+ sky130_fd_sc_hd__clkbuf_16
Xclkbuf_4_6_0_clk clknet_0_clk VSS VSS VDD VDD clknet_4_6_0_clk
+ sky130_fd_sc_hd__clkbuf_16
Xclkbuf_4_7_0_clk clknet_0_clk VSS VSS VDD VDD clknet_4_7_0_clk
+ sky130_fd_sc_hd__clkbuf_16
Xclkbuf_4_8_0_clk clknet_0_clk VSS VSS VDD VDD clknet_4_8_0_clk
+ sky130_fd_sc_hd__clkbuf_16
Xclkbuf_4_9_0_clk clknet_0_clk VSS VSS VDD VDD clknet_4_9_0_clk
+ sky130_fd_sc_hd__clkbuf_16
Xclkbuf_4_10_0_clk clknet_0_clk VSS VSS VDD VDD clknet_4_10_0_clk
+ sky130_fd_sc_hd__clkbuf_16
Xclkbuf_4_11_0_clk clknet_0_clk VSS VSS VDD VDD clknet_4_11_0_clk
+ sky130_fd_sc_hd__clkbuf_16
Xclkbuf_4_12_0_clk clknet_0_clk VSS VSS VDD VDD clknet_4_12_0_clk
+ sky130_fd_sc_hd__clkbuf_16
Xclkbuf_4_13_0_clk clknet_0_clk VSS VSS VDD VDD clknet_4_13_0_clk
+ sky130_fd_sc_hd__clkbuf_16
Xclkbuf_4_14_0_clk clknet_0_clk VSS VSS VDD VDD clknet_4_14_0_clk
+ sky130_fd_sc_hd__clkbuf_16
Xclkbuf_4_15_0_clk clknet_0_clk VSS VSS VDD VDD clknet_4_15_0_clk
+ sky130_fd_sc_hd__clkbuf_16
Xclkload0 clknet_4_0_0_clk VSS VSS VDD VDD _unconnected_0
+ sky130_fd_sc_hd__clkbuf_1
Xclkload1 clknet_4_1_0_clk VSS VSS VDD VDD _unconnected_1
+ sky130_fd_sc_hd__clkinv_2
Xclkload2 clknet_4_2_0_clk VSS VSS VDD VDD _unconnected_2
+ sky130_fd_sc_hd__inv_6
Xclkload3 clknet_4_3_0_clk VSS VSS VDD VDD _unconnected_3
+ sky130_fd_sc_hd__bufinv_16
Xclkload4 clknet_4_4_0_clk VSS VSS VDD VDD _unconnected_4
+ sky130_fd_sc_hd__clkinvlp_4
Xclkload5 clknet_4_5_0_clk VSS VSS VDD VDD _unconnected_5
+ sky130_fd_sc_hd__clkinv_2
Xclkload6 clknet_4_6_0_clk VSS VSS VDD VDD _unconnected_6
+ sky130_fd_sc_hd__clkinv_2
Xclkload7 clknet_4_8_0_clk VSS VSS VDD VDD _unconnected_7
+ sky130_fd_sc_hd__clkbuf_8
Xclkload8 clknet_4_10_0_clk VSS VSS VDD VDD _unconnected_8
+ sky130_fd_sc_hd__bufinv_16
Xclkload9 clknet_4_11_0_clk VSS VSS VDD VDD _unconnected_9
+ sky130_fd_sc_hd__clkinv_4
Xclkload10 clknet_4_12_0_clk VSS VSS VDD VDD _unconnected_10
+ sky130_fd_sc_hd__bufinv_16
Xclkload11 clknet_4_13_0_clk VSS VSS VDD VDD _unconnected_11
+ sky130_fd_sc_hd__clkbuf_8
Xclkload12 clknet_4_14_0_clk VSS VSS VDD VDD _unconnected_12
+ sky130_fd_sc_hd__clkinvlp_4
Xclkload13 clknet_4_15_0_clk VSS VSS VDD VDD _unconnected_13
+ sky130_fd_sc_hd__inv_6
.ENDS systolic2x2
